* Copyright 2026 FOSSi Foundation
*
* Licensed under the Apache License, Version 2.0 (the "License");
* you may not use this file except in compliance with the License.
* You may obtain a copy of the License at
*
*	https://www.apache.org/licenses/LICENSE-2.0
*
* Unless required by applicable law or agreed to in writing, software
* distributed under the License is distributed on an "AS IS" BASIS,
* WITHOUT WARRANTIES OR CONDITIONS OF ANY KIND, either express or implied.
* See the License for the specific language governing permissions and
* limitations under the License.
*
* SPDX-License-Identifier: Apache-2.0
* NGSPICE file created from sky130_fd_sc_hvl__sdlxtp_1.ext - technology: sky130A

.subckt sky130_fd_sc_hvl__sdlxtp_1 D GATE SCD SCE VGND VNB VPB VPWR Q
X0 a_1480_107# a_1214_107# a_489_107# VNB sky130_fd_pr__nfet_g5v0d10v5 ad=0.0588 pd=0.7 as=0.1113 ps=1.37 w=0.42 l=0.5
X1 a_1724_593# a_1214_107# a_1480_107# VPB sky130_fd_pr__pfet_g5v0d10v5 ad=0.0441 pd=0.63 as=0.12998 ps=1.145 w=0.42 l=0.5
X2 VPWR a_1678_81# a_1724_593# VPB sky130_fd_pr__pfet_g5v0d10v5 ad=0.1197 pd=1.41 as=0.0441 ps=0.63 w=0.42 l=0.5
X3 VGND SCE a_30_587# VNB sky130_fd_pr__nfet_g5v0d10v5 ad=0.0588 pd=0.7 as=0.1197 ps=1.41 w=0.42 l=0.5
X4 a_1214_107# a_944_107# VGND VNB sky130_fd_pr__nfet_g5v0d10v5 ad=0.1113 pd=1.37 as=0.1197 ps=1.41 w=0.42 l=0.5
X5 a_660_587# a_30_587# a_489_107# VPB sky130_fd_pr__pfet_g5v0d10v5 ad=0.07875 pd=0.96 as=0.105 ps=1.03 w=0.75 l=0.5
X6 a_944_107# GATE VGND VNB sky130_fd_pr__nfet_g5v0d10v5 ad=0.1113 pd=1.37 as=0.05985 ps=0.705 w=0.42 l=0.5
X7 a_645_107# SCE a_489_107# VNB sky130_fd_pr__nfet_g5v0d10v5 ad=0.0441 pd=0.63 as=0.0588 ps=0.7 w=0.42 l=0.5
X8 VGND SCD a_645_107# VNB sky130_fd_pr__nfet_g5v0d10v5 ad=0.05985 pd=0.705 as=0.0441 ps=0.63 w=0.42 l=0.5
X9 a_1480_107# a_944_107# a_489_107# VPB sky130_fd_pr__pfet_g5v0d10v5 ad=0.12998 pd=1.145 as=0.21375 ps=2.07 w=0.75 l=0.5
X10 a_362_587# SCE VPWR VPB sky130_fd_pr__pfet_g5v0d10v5 ad=0.07875 pd=0.96 as=0.12247 ps=1.125 w=0.75 l=0.5
X11 VPWR a_1480_107# a_1678_81# VPB sky130_fd_pr__pfet_g5v0d10v5 ad=0.23685 pd=1.895 as=0.1197 ps=1.41 w=0.42 l=0.5
X12 VPWR SCD a_660_587# VPB sky130_fd_pr__pfet_g5v0d10v5 ad=0.105 pd=1.03 as=0.07875 ps=0.96 w=0.75 l=0.5
X13 VGND a_1480_107# a_1678_81# VNB sky130_fd_pr__nfet_g5v0d10v5 ad=0.12247 pd=1.125 as=0.1113 ps=1.37 w=0.42 l=0.5
X14 a_347_107# D VGND VNB sky130_fd_pr__nfet_g5v0d10v5 ad=0.0441 pd=0.63 as=0.0588 ps=0.7 w=0.42 l=0.5
X15 a_489_107# a_30_587# a_347_107# VNB sky130_fd_pr__nfet_g5v0d10v5 ad=0.0588 pd=0.7 as=0.0441 ps=0.63 w=0.42 l=0.5
X16 a_1214_107# a_944_107# VPWR VPB sky130_fd_pr__pfet_g5v0d10v5 ad=0.21375 pd=2.07 as=0.21375 ps=2.07 w=0.75 l=0.5
X17 a_489_107# D a_362_587# VPB sky130_fd_pr__pfet_g5v0d10v5 ad=0.105 pd=1.03 as=0.07875 ps=0.96 w=0.75 l=0.5
X18 VPWR SCE a_30_587# VPB sky130_fd_pr__pfet_g5v0d10v5 ad=0.12247 pd=1.125 as=0.1197 ps=1.41 w=0.42 l=0.5
X19 a_1636_107# a_944_107# a_1480_107# VNB sky130_fd_pr__nfet_g5v0d10v5 ad=0.0441 pd=0.63 as=0.0588 ps=0.7 w=0.42 l=0.5
X20 Q a_1480_107# VGND VNB sky130_fd_pr__nfet_g5v0d10v5 ad=0.19875 pd=2.03 as=0.12247 ps=1.125 w=0.75 l=0.5
X21 VGND a_1678_81# a_1636_107# VNB sky130_fd_pr__nfet_g5v0d10v5 ad=0.1113 pd=1.37 as=0.0441 ps=0.63 w=0.42 l=0.5
X22 Q a_1480_107# VPWR VPB sky130_fd_pr__pfet_g5v0d10v5 ad=0.4275 pd=3.57 as=0.23685 ps=1.895 w=1.5 l=0.5
X23 a_944_107# GATE VPWR VPB sky130_fd_pr__pfet_g5v0d10v5 ad=0.21375 pd=2.07 as=0.105 ps=1.03 w=0.75 l=0.5
.ends
