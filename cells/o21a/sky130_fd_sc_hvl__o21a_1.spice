* Copyright 2026 FOSSi Foundation
*
* Licensed under the Apache License, Version 2.0 (the "License");
* you may not use this file except in compliance with the License.
* You may obtain a copy of the License at
*
*	https://www.apache.org/licenses/LICENSE-2.0
*
* Unless required by applicable law or agreed to in writing, software
* distributed under the License is distributed on an "AS IS" BASIS,
* WITHOUT WARRANTIES OR CONDITIONS OF ANY KIND, either express or implied.
* See the License for the specific language governing permissions and
* limitations under the License.
*
* SPDX-License-Identifier: Apache-2.0
* NGSPICE file created from sky130_fd_sc_hvl__o21a_1.ext - technology: sky130A

.subckt sky130_fd_sc_hvl__o21a_1 A1 A2 B1 VGND VNB VPB VPWR X
X0 VGND a_83_87# X VNB sky130_fd_pr__nfet_g5v0d10v5 ad=0.21375 pd=2.07 as=0.19875 ps=2.03 w=0.75 l=0.5
X1 VGND A2 a_460_107# VNB sky130_fd_pr__nfet_g5v0d10v5 ad=0.1125 pd=1.05 as=0.105 ps=1.03 w=0.75 l=0.5
X2 a_602_443# A2 a_83_87# VPB sky130_fd_pr__pfet_g5v0d10v5 ad=0.21 pd=1.78 as=0.27 ps=1.86 w=1.5 l=0.5
X3 VPWR a_83_87# X VPB sky130_fd_pr__pfet_g5v0d10v5 ad=0.375 pd=2 as=0.4275 ps=3.57 w=1.5 l=0.5
X4 a_460_107# A1 VGND VNB sky130_fd_pr__nfet_g5v0d10v5 ad=0.21375 pd=2.07 as=0.1125 ps=1.05 w=0.75 l=0.5
X5 a_460_107# B1 a_83_87# VNB sky130_fd_pr__nfet_g5v0d10v5 ad=0.105 pd=1.03 as=0.21375 ps=2.07 w=0.75 l=0.5
X6 a_83_87# B1 VPWR VPB sky130_fd_pr__pfet_g5v0d10v5 ad=0.27 pd=1.86 as=0.375 ps=2 w=1.5 l=0.5
X7 VPWR A1 a_602_443# VPB sky130_fd_pr__pfet_g5v0d10v5 ad=0.4275 pd=3.57 as=0.21 ps=1.78 w=1.5 l=0.5
.ends
