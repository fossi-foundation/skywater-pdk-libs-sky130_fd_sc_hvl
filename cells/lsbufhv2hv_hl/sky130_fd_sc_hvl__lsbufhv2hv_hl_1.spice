* Copyright 2026 FOSSi Foundation
*
* Licensed under the Apache License, Version 2.0 (the "License");
* you may not use this file except in compliance with the License.
* You may obtain a copy of the License at
*
*	https://www.apache.org/licenses/LICENSE-2.0
*
* Unless required by applicable law or agreed to in writing, software
* distributed under the License is distributed on an "AS IS" BASIS,
* WITHOUT WARRANTIES OR CONDITIONS OF ANY KIND, either express or implied.
* See the License for the specific language governing permissions and
* limitations under the License.
*
* SPDX-License-Identifier: Apache-2.0
* NGSPICE file created from sky130_fd_sc_hvl__lsbufhv2hv_hl_1.ext - technology: sky130A

.subckt sky130_fd_sc_hvl__lsbufhv2hv_hl_1 A LOWHVPWR VGND VNB VPB VPWR X
X0 a_662_81# A VGND VNB sky130_fd_pr__nfet_g5v0d10v5 ad=0.1197 pd=1.41 as=0.15202 ps=1.25 w=0.42 l=0.5
X1 a_662_81# A LOWHVPWR LOWHVPWR sky130_fd_pr__pfet_g5v0d10v5 ad=0.21375 pd=2.07 as=0.255 ps=1.895 w=0.75 l=0.5
X2 LOWHVPWR a_662_81# X LOWHVPWR sky130_fd_pr__pfet_g5v0d10v5 ad=0.255 pd=1.895 as=0.4275 ps=3.57 w=1.5 l=0.5
X3 VGND a_662_81# X VNB sky130_fd_pr__nfet_g5v0d10v5 ad=0.15202 pd=1.25 as=0.19875 ps=2.03 w=0.75 l=0.5
.ends
