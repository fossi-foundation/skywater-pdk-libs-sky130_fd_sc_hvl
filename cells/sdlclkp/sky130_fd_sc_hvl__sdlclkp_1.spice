* Copyright 2026 FOSSi Foundation
*
* Licensed under the Apache License, Version 2.0 (the "License");
* you may not use this file except in compliance with the License.
* You may obtain a copy of the License at
*
*	https://www.apache.org/licenses/LICENSE-2.0
*
* Unless required by applicable law or agreed to in writing, software
* distributed under the License is distributed on an "AS IS" BASIS,
* WITHOUT WARRANTIES OR CONDITIONS OF ANY KIND, either express or implied.
* See the License for the specific language governing permissions and
* limitations under the License.
*
* SPDX-License-Identifier: Apache-2.0
* NGSPICE file created from sky130_fd_sc_hvl__sdlclkp_1.ext - technology: sky130A

.subckt sky130_fd_sc_hvl__sdlclkp_1 CLK GATE SCE VGND VNB VPB VPWR GCLK
X0 VGND SCE a_58_159# VNB sky130_fd_pr__nfet_g5v0d10v5 ad=0.0588 pd=0.7 as=0.1281 ps=1.45 w=0.42 l=0.5
X1 a_423_71# CLK VGND VNB sky130_fd_pr__nfet_g5v0d10v5 ad=0.1113 pd=1.37 as=0.0588 ps=0.7 w=0.42 l=0.5
X2 a_1219_159# a_431_431# a_495_311# VNB sky130_fd_pr__nfet_g5v0d10v5 ad=0.0441 pd=0.63 as=0.1113 ps=1.37 w=0.42 l=0.5
X3 VGND a_1261_133# a_1219_159# VNB sky130_fd_pr__nfet_g5v0d10v5 ad=0.0588 pd=0.7 as=0.0441 ps=0.63 w=0.42 l=0.5
X4 a_1630_171# a_1261_133# VPWR VPB sky130_fd_pr__pfet_g5v0d10v5 ad=0.105 pd=1.03 as=0.19875 ps=2.03 w=0.75 l=0.5
X5 VGND CLK a_1783_171# VNB sky130_fd_pr__nfet_g5v0d10v5 ad=0.11513 pd=1.09 as=0.0588 ps=0.7 w=0.42 l=0.5
X6 a_495_311# a_423_71# a_58_159# VNB sky130_fd_pr__nfet_g5v0d10v5 ad=0.1113 pd=1.37 as=0.0588 ps=0.7 w=0.42 l=0.5
X7 a_423_71# CLK VPWR VPB sky130_fd_pr__pfet_g5v0d10v5 ad=0.19875 pd=2.03 as=0.105 ps=1.03 w=0.75 l=0.5
X8 a_1261_133# a_495_311# VPWR VPB sky130_fd_pr__pfet_g5v0d10v5 ad=0.1113 pd=1.37 as=0.0588 ps=0.7 w=0.42 l=0.5
X9 VGND a_423_71# a_431_431# VNB sky130_fd_pr__nfet_g5v0d10v5 ad=0.0588 pd=0.7 as=0.1113 ps=1.37 w=0.42 l=0.5
X10 a_1783_171# a_1261_133# a_1630_171# VNB sky130_fd_pr__nfet_g5v0d10v5 ad=0.0588 pd=0.7 as=0.1113 ps=1.37 w=0.42 l=0.5
X11 a_219_457# SCE VPWR VPB sky130_fd_pr__pfet_g5v0d10v5 ad=0.105 pd=1.03 as=0.22875 ps=2.11 w=0.75 l=0.5
X12 GCLK a_1630_171# VPWR VPB sky130_fd_pr__pfet_g5v0d10v5 ad=0.3975 pd=3.53 as=0.22688 ps=1.84 w=1.5 l=0.5
X13 a_58_159# GATE VGND VNB sky130_fd_pr__nfet_g5v0d10v5 ad=0.0588 pd=0.7 as=0.0588 ps=0.7 w=0.42 l=0.5
X14 VPWR a_423_71# a_431_431# VPB sky130_fd_pr__pfet_g5v0d10v5 ad=0.105 pd=1.03 as=0.19875 ps=2.03 w=0.75 l=0.5
X15 a_1219_457# a_423_71# a_495_311# VPB sky130_fd_pr__pfet_g5v0d10v5 ad=0.0441 pd=0.63 as=0.1113 ps=1.37 w=0.42 l=0.5
X16 VPWR a_1261_133# a_1219_457# VPB sky130_fd_pr__pfet_g5v0d10v5 ad=0.0588 pd=0.7 as=0.0441 ps=0.63 w=0.42 l=0.5
X17 a_495_311# a_431_431# a_58_159# VPB sky130_fd_pr__pfet_g5v0d10v5 ad=0.19875 pd=2.03 as=0.105 ps=1.03 w=0.75 l=0.5
X18 a_1261_133# a_495_311# VGND VNB sky130_fd_pr__nfet_g5v0d10v5 ad=0.1113 pd=1.37 as=0.0588 ps=0.7 w=0.42 l=0.5
X19 a_58_159# GATE a_219_457# VPB sky130_fd_pr__pfet_g5v0d10v5 ad=0.105 pd=1.03 as=0.105 ps=1.03 w=0.75 l=0.5
X20 VPWR CLK a_1630_171# VPB sky130_fd_pr__pfet_g5v0d10v5 ad=0.22688 pd=1.84 as=0.105 ps=1.03 w=0.75 l=0.5
X21 GCLK a_1630_171# VGND VNB sky130_fd_pr__nfet_g5v0d10v5 ad=0.19875 pd=2.03 as=0.11513 ps=1.09 w=0.75 l=0.5
.ends
