* Copyright 2026 FOSSi Foundation
*
* Licensed under the Apache License, Version 2.0 (the "License");
* you may not use this file except in compliance with the License.
* You may obtain a copy of the License at
*
*	https://www.apache.org/licenses/LICENSE-2.0
*
* Unless required by applicable law or agreed to in writing, software
* distributed under the License is distributed on an "AS IS" BASIS,
* WITHOUT WARRANTIES OR CONDITIONS OF ANY KIND, either express or implied.
* See the License for the specific language governing permissions and
* limitations under the License.
*
* SPDX-License-Identifier: Apache-2.0
* NGSPICE file created from sky130_fd_sc_hvl__sdfstp_1.ext - technology: sky130A

.subckt sky130_fd_sc_hvl__sdfstp_1 CLK D SCD SCE SET_B VGND VNB VPB VPWR Q
X0 VPWR a_1669_87# a_1686_543# VPB sky130_fd_pr__pfet_g5v0d10v5 ad=0.0756 pd=0.78 as=0.0441 ps=0.63 w=0.42 l=0.5
X1 a_339_107# D VGND VNB sky130_fd_pr__nfet_g5v0d10v5 ad=0.0441 pd=0.63 as=0.0588 ps=0.7 w=0.42 l=0.5
X2 a_481_107# a_30_107# a_339_107# VNB sky130_fd_pr__nfet_g5v0d10v5 ad=0.0588 pd=0.7 as=0.0441 ps=0.63 w=0.42 l=0.5
X3 VGND SET_B a_2035_107# VNB sky130_fd_pr__nfet_g5v0d10v5 ad=0.12247 pd=1.125 as=0.0441 ps=0.63 w=0.42 l=0.5
X4 a_1471_113# a_1201_123# a_481_107# VPB sky130_fd_pr__pfet_g5v0d10v5 ad=0.0588 pd=0.7 as=0.1197 ps=1.41 w=0.42 l=0.5
X5 a_2656_543# a_1201_123# a_2477_543# VPB sky130_fd_pr__pfet_g5v0d10v5 ad=0.0441 pd=0.63 as=0.1656 ps=1.395 w=0.42 l=0.5
X6 a_2352_107# a_1471_113# VGND VNB sky130_fd_pr__nfet_g5v0d10v5 ad=0.07875 pd=0.96 as=0.12247 ps=1.125 w=0.75 l=0.5
X7 a_2812_173# a_2698_421# a_2669_173# VNB sky130_fd_pr__nfet_g5v0d10v5 ad=0.0441 pd=0.63 as=0.04515 ps=0.635 w=0.42 l=0.5
X8 a_935_107# CLK VPWR VPB sky130_fd_pr__pfet_g5v0d10v5 ad=0.21375 pd=2.07 as=0.12998 ps=1.145 w=0.75 l=0.5
X9 VPWR a_2698_421# a_2656_543# VPB sky130_fd_pr__pfet_g5v0d10v5 ad=0.0588 pd=0.7 as=0.0441 ps=0.63 w=0.42 l=0.5
X10 a_2477_543# a_1201_123# a_2352_107# VNB sky130_fd_pr__nfet_g5v0d10v5 ad=0.12247 pd=1.125 as=0.07875 ps=0.96 w=0.75 l=0.5
X11 VGND SET_B a_2812_173# VNB sky130_fd_pr__nfet_g5v0d10v5 ad=0.09345 pd=0.865 as=0.0441 ps=0.63 w=0.42 l=0.5
X12 VPWR SCE a_30_107# VPB sky130_fd_pr__pfet_g5v0d10v5 ad=0.0588 pd=0.7 as=0.1113 ps=1.37 w=0.42 l=0.5
X13 a_2035_107# a_1471_113# a_1669_87# VNB sky130_fd_pr__nfet_g5v0d10v5 ad=0.0441 pd=0.63 as=0.1113 ps=1.37 w=0.42 l=0.5
X14 a_1669_87# a_1471_113# VPWR VPB sky130_fd_pr__pfet_g5v0d10v5 ad=0.0588 pd=0.7 as=0.0756 ps=0.78 w=0.42 l=0.5
X15 a_2335_543# a_1471_113# VPWR VPB sky130_fd_pr__pfet_g5v0d10v5 ad=0.105 pd=1.21 as=0.1656 ps=1.395 w=1 l=0.5
X16 a_637_569# a_30_107# a_481_107# VPB sky130_fd_pr__pfet_g5v0d10v5 ad=0.0441 pd=0.63 as=0.0588 ps=0.7 w=0.42 l=0.5
X17 a_2477_543# a_935_107# a_2335_543# VPB sky130_fd_pr__pfet_g5v0d10v5 ad=0.1656 pd=1.395 as=0.105 ps=1.21 w=1 l=0.5
X18 VPWR a_2477_543# a_2698_421# VPB sky130_fd_pr__pfet_g5v0d10v5 ad=0.1113 pd=1.37 as=0.1113 ps=1.37 w=0.42 l=0.5
X19 a_2698_421# a_2477_543# VGND VNB sky130_fd_pr__nfet_g5v0d10v5 ad=0.1197 pd=1.41 as=0.09345 ps=0.865 w=0.42 l=0.5
X20 VPWR SCD a_637_569# VPB sky130_fd_pr__pfet_g5v0d10v5 ad=0.12998 pd=1.145 as=0.0441 ps=0.63 w=0.42 l=0.5
X21 a_1627_113# a_1201_123# a_1471_113# VNB sky130_fd_pr__nfet_g5v0d10v5 ad=0.0441 pd=0.63 as=0.0588 ps=0.7 w=0.42 l=0.5
X22 a_935_107# CLK VGND VNB sky130_fd_pr__nfet_g5v0d10v5 ad=0.1113 pd=1.37 as=0.0588 ps=0.7 w=0.42 l=0.5
X23 VGND a_1669_87# a_1627_113# VNB sky130_fd_pr__nfet_g5v0d10v5 ad=0.1113 pd=1.37 as=0.0441 ps=0.63 w=0.42 l=0.5
X24 a_1686_543# a_935_107# a_1471_113# VPB sky130_fd_pr__pfet_g5v0d10v5 ad=0.0441 pd=0.63 as=0.0588 ps=0.7 w=0.42 l=0.5
X25 VPWR SET_B a_1669_87# VPB sky130_fd_pr__pfet_g5v0d10v5 ad=0.1656 pd=1.395 as=0.0588 ps=0.7 w=0.42 l=0.5
X26 VGND SCE a_30_107# VNB sky130_fd_pr__nfet_g5v0d10v5 ad=0.0588 pd=0.7 as=0.1113 ps=1.37 w=0.42 l=0.5
X27 VGND a_2477_543# a_3321_173# VNB sky130_fd_pr__nfet_g5v0d10v5 ad=0.12998 pd=1.145 as=0.1197 ps=1.41 w=0.42 l=0.5
X28 a_339_569# SCE VPWR VPB sky130_fd_pr__pfet_g5v0d10v5 ad=0.0441 pd=0.63 as=0.0588 ps=0.7 w=0.42 l=0.5
X29 a_481_107# D a_339_569# VPB sky130_fd_pr__pfet_g5v0d10v5 ad=0.0588 pd=0.7 as=0.0441 ps=0.63 w=0.42 l=0.5
X30 a_1471_113# a_935_107# a_481_107# VNB sky130_fd_pr__nfet_g5v0d10v5 ad=0.0588 pd=0.7 as=0.1197 ps=1.41 w=0.42 l=0.5
X31 a_2669_173# a_935_107# a_2477_543# VNB sky130_fd_pr__nfet_g5v0d10v5 ad=0.04515 pd=0.635 as=0.12247 ps=1.125 w=0.42 l=0.5
X32 a_637_107# SCE a_481_107# VNB sky130_fd_pr__nfet_g5v0d10v5 ad=0.0441 pd=0.63 as=0.0588 ps=0.7 w=0.42 l=0.5
X33 a_1201_123# a_935_107# VGND VNB sky130_fd_pr__nfet_g5v0d10v5 ad=0.1113 pd=1.37 as=0.1113 ps=1.37 w=0.42 l=0.5
X34 VPWR a_2477_543# a_3321_173# VPB sky130_fd_pr__pfet_g5v0d10v5 ad=0.17375 pd=1.375 as=0.19875 ps=2.03 w=0.75 l=0.5
X35 VGND SCD a_637_107# VNB sky130_fd_pr__nfet_g5v0d10v5 ad=0.0588 pd=0.7 as=0.0441 ps=0.63 w=0.42 l=0.5
X36 Q a_3321_173# VPWR VPB sky130_fd_pr__pfet_g5v0d10v5 ad=0.265 pd=2.53 as=0.17375 ps=1.375 w=1 l=0.5
X37 a_1201_123# a_935_107# VPWR VPB sky130_fd_pr__pfet_g5v0d10v5 ad=0.21375 pd=2.07 as=0.21375 ps=2.07 w=0.75 l=0.5
X38 a_2477_543# SET_B VPWR VPB sky130_fd_pr__pfet_g5v0d10v5 ad=0.1113 pd=1.37 as=0.0588 ps=0.7 w=0.42 l=0.5
X39 Q a_3321_173# VGND VNB sky130_fd_pr__nfet_g5v0d10v5 ad=0.21375 pd=2.07 as=0.12998 ps=1.145 w=0.75 l=0.5
.ends
