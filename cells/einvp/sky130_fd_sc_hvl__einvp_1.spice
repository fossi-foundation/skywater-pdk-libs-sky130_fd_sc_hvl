* Copyright 2026 FOSSi Foundation
*
* Licensed under the Apache License, Version 2.0 (the "License");
* you may not use this file except in compliance with the License.
* You may obtain a copy of the License at
*
*	https://www.apache.org/licenses/LICENSE-2.0
*
* Unless required by applicable law or agreed to in writing, software
* distributed under the License is distributed on an "AS IS" BASIS,
* WITHOUT WARRANTIES OR CONDITIONS OF ANY KIND, either express or implied.
* See the License for the specific language governing permissions and
* limitations under the License.
*
* SPDX-License-Identifier: Apache-2.0
* NGSPICE file created from sky130_fd_sc_hvl__einvp_1.ext - technology: sky130A

.subckt sky130_fd_sc_hvl__einvp_1 A TE VGND VNB VPB VPWR Z
X0 Z A a_413_443# VPB sky130_fd_pr__pfet_g5v0d10v5 ad=0.4275 pd=3.57 as=0.27 ps=1.86 w=1.5 l=0.5
X1 a_413_123# TE VGND VNB sky130_fd_pr__nfet_g5v0d10v5 ad=0.135 pd=1.11 as=0.17932 ps=1.38 w=0.75 l=0.5
X2 VPWR TE a_30_189# VPB sky130_fd_pr__pfet_g5v0d10v5 ad=0.24938 pd=1.88 as=0.21375 ps=2.07 w=0.75 l=0.5
X3 Z A a_413_123# VNB sky130_fd_pr__nfet_g5v0d10v5 ad=0.21375 pd=2.07 as=0.135 ps=1.11 w=0.75 l=0.5
X4 VGND TE a_30_189# VNB sky130_fd_pr__nfet_g5v0d10v5 ad=0.17932 pd=1.38 as=0.1197 ps=1.41 w=0.42 l=0.5
X5 a_413_443# a_30_189# VPWR VPB sky130_fd_pr__pfet_g5v0d10v5 ad=0.27 pd=1.86 as=0.24938 ps=1.88 w=1.5 l=0.5
.ends
