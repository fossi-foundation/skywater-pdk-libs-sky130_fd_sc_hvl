* Copyright 2026 FOSSi Foundation
*
* Licensed under the Apache License, Version 2.0 (the "License");
* you may not use this file except in compliance with the License.
* You may obtain a copy of the License at
*
*	https://www.apache.org/licenses/LICENSE-2.0
*
* Unless required by applicable law or agreed to in writing, software
* distributed under the License is distributed on an "AS IS" BASIS,
* WITHOUT WARRANTIES OR CONDITIONS OF ANY KIND, either express or implied.
* See the License for the specific language governing permissions and
* limitations under the License.
*
* SPDX-License-Identifier: Apache-2.0
* NGSPICE file created from sky130_fd_sc_hvl__sdfrtp_1.ext - technology: sky130A

.subckt sky130_fd_sc_hvl__sdfrtp_1 CLK D RESET_B SCD SCE VGND VNB VPB VPWR Q
X0 a_1468_126# a_1212_471# a_1312_126# VNB sky130_fd_pr__nfet_g5v0d10v5 ad=0.0441 pd=0.63 as=0.0588 ps=0.7 w=0.42 l=0.5
X1 a_294_126# SCD a_137_126# VNB sky130_fd_pr__nfet_g5v0d10v5 ad=0.0441 pd=0.63 as=0.1197 ps=1.41 w=0.42 l=0.5
X2 a_137_126# D a_592_126# VNB sky130_fd_pr__nfet_g5v0d10v5 ad=0.0588 pd=0.7 as=0.0441 ps=0.63 w=0.42 l=0.5
X3 VGND a_2360_115# a_3417_443# VNB sky130_fd_pr__nfet_g5v0d10v5 ad=0.12247 pd=1.125 as=0.1197 ps=1.41 w=0.42 l=0.5
X4 a_1510_100# a_1312_126# VGND VNB sky130_fd_pr__nfet_g5v0d10v5 ad=0.105 pd=1.03 as=0.1356 ps=1.16 w=0.75 l=0.5
X5 a_1468_641# a_1212_100# a_1312_126# VPB sky130_fd_pr__pfet_g5v0d10v5 ad=0.0441 pd=0.63 as=0.0588 ps=0.7 w=0.42 l=0.5
X6 a_2616_417# RESET_B VPWR VPB sky130_fd_pr__pfet_g5v0d10v5 ad=0.0588 pd=0.7 as=0.15692 ps=1.305 w=0.42 l=0.5
X7 a_1610_126# a_1510_100# a_1468_126# VNB sky130_fd_pr__nfet_g5v0d10v5 ad=0.0441 pd=0.63 as=0.0441 ps=0.63 w=0.42 l=0.5
X8 a_116_451# SCE VGND VNB sky130_fd_pr__nfet_g5v0d10v5 ad=0.1113 pd=1.37 as=0.0588 ps=0.7 w=0.42 l=0.5
X9 a_65_649# SCE a_294_126# VNB sky130_fd_pr__nfet_g5v0d10v5 ad=0.0588 pd=0.7 as=0.0441 ps=0.63 w=0.42 l=0.5
X10 VGND RESET_B a_1610_126# VNB sky130_fd_pr__nfet_g5v0d10v5 ad=0.1197 pd=1.41 as=0.0441 ps=0.63 w=0.42 l=0.5
X11 a_222_649# a_116_451# a_65_649# VPB sky130_fd_pr__pfet_g5v0d10v5 ad=0.0441 pd=0.63 as=0.1197 ps=1.41 w=0.42 l=0.5
X12 a_1510_100# a_1312_126# VPWR VPB sky130_fd_pr__pfet_g5v0d10v5 ad=0.14 pd=1.28 as=0.17375 ps=1.375 w=1 l=0.5
X13 VPWR SCD a_222_649# VPB sky130_fd_pr__pfet_g5v0d10v5 ad=0.063 pd=0.72 as=0.0441 ps=0.63 w=0.42 l=0.5
X14 a_116_451# SCE VPWR VPB sky130_fd_pr__pfet_g5v0d10v5 ad=0.1197 pd=1.41 as=0.1197 ps=0.99 w=0.42 l=0.5
X15 VPWR a_1510_100# a_1468_641# VPB sky130_fd_pr__pfet_g5v0d10v5 ad=0.0756 pd=0.78 as=0.0441 ps=0.63 w=0.42 l=0.5
X16 Q a_3417_443# VPWR VPB sky130_fd_pr__pfet_g5v0d10v5 ad=0.4275 pd=3.57 as=0.255 ps=1.895 w=1.5 l=0.5
X17 VGND a_2616_417# a_2539_181# VNB sky130_fd_pr__nfet_g5v0d10v5 ad=0.0609 pd=0.71 as=0.11235 ps=0.955 w=0.42 l=0.5
X18 a_1212_100# CLK VPWR VPB sky130_fd_pr__pfet_g5v0d10v5 ad=0.21375 pd=2.07 as=0.14992 ps=1.24 w=0.75 l=0.5
X19 VGND RESET_B a_137_126# VNB sky130_fd_pr__nfet_g5v0d10v5 ad=0.0588 pd=0.7 as=0.0588 ps=0.7 w=0.42 l=0.5
X20 a_1312_126# a_1212_100# a_65_649# VNB sky130_fd_pr__nfet_g5v0d10v5 ad=0.0588 pd=0.7 as=0.1113 ps=1.37 w=0.42 l=0.5
X21 VPWR RESET_B a_65_649# VPB sky130_fd_pr__pfet_g5v0d10v5 ad=0.1197 pd=0.99 as=0.0588 ps=0.7 w=0.42 l=0.5
X22 VPWR a_1212_100# a_1212_471# VPB sky130_fd_pr__pfet_g5v0d10v5 ad=0.17375 pd=1.375 as=0.19875 ps=2.03 w=0.75 l=0.5
X23 a_2904_181# RESET_B VGND VNB sky130_fd_pr__nfet_g5v0d10v5 ad=0.0441 pd=0.63 as=0.0609 ps=0.71 w=0.42 l=0.5
X24 a_2360_115# a_1212_471# a_1510_100# VNB sky130_fd_pr__nfet_g5v0d10v5 ad=0.12998 pd=1.145 as=0.105 ps=1.03 w=0.75 l=0.5
X25 a_2616_417# a_2360_115# a_2904_181# VNB sky130_fd_pr__nfet_g5v0d10v5 ad=0.1113 pd=1.37 as=0.0441 ps=0.63 w=0.42 l=0.5
X26 VGND a_1212_100# a_1212_471# VNB sky130_fd_pr__nfet_g5v0d10v5 ad=0.1356 pd=1.16 as=0.1113 ps=1.37 w=0.42 l=0.5
X27 a_2574_543# a_1212_471# a_2360_115# VPB sky130_fd_pr__pfet_g5v0d10v5 ad=0.0441 pd=0.63 as=0.1956 ps=1.455 w=0.42 l=0.5
X28 VGND CLK a_1212_100# VNB sky130_fd_pr__nfet_g5v0d10v5 ad=0.1113 pd=1.37 as=0.1113 ps=1.37 w=0.42 l=0.5
X29 Q a_3417_443# VGND VNB sky130_fd_pr__nfet_g5v0d10v5 ad=0.19875 pd=2.03 as=0.12247 ps=1.125 w=0.75 l=0.5
X30 a_1312_126# a_1212_471# a_65_649# VPB sky130_fd_pr__pfet_g5v0d10v5 ad=0.0588 pd=0.7 as=0.1197 ps=1.41 w=0.42 l=0.5
X31 a_1312_126# RESET_B VPWR VPB sky130_fd_pr__pfet_g5v0d10v5 ad=0.1197 pd=1.41 as=0.0756 ps=0.78 w=0.42 l=0.5
X32 VPWR a_2360_115# a_2616_417# VPB sky130_fd_pr__pfet_g5v0d10v5 ad=0.14992 pd=1.24 as=0.0588 ps=0.7 w=0.42 l=0.5
X33 VPWR a_2360_115# a_3417_443# VPB sky130_fd_pr__pfet_g5v0d10v5 ad=0.255 pd=1.895 as=0.21375 ps=2.07 w=0.75 l=0.5
X34 a_592_126# a_116_451# a_65_649# VNB sky130_fd_pr__nfet_g5v0d10v5 ad=0.0441 pd=0.63 as=0.0588 ps=0.7 w=0.42 l=0.5
X35 a_524_649# SCE VPWR VPB sky130_fd_pr__pfet_g5v0d10v5 ad=0.0441 pd=0.63 as=0.063 ps=0.72 w=0.42 l=0.5
X36 a_2360_115# a_1212_100# a_1510_100# VPB sky130_fd_pr__pfet_g5v0d10v5 ad=0.1956 pd=1.455 as=0.14 ps=1.28 w=1 l=0.5
X37 a_65_649# D a_524_649# VPB sky130_fd_pr__pfet_g5v0d10v5 ad=0.0588 pd=0.7 as=0.0441 ps=0.63 w=0.42 l=0.5
X38 a_2539_181# a_1212_100# a_2360_115# VNB sky130_fd_pr__nfet_g5v0d10v5 ad=0.11235 pd=0.955 as=0.12998 ps=1.145 w=0.42 l=0.5
X39 VPWR a_2616_417# a_2574_543# VPB sky130_fd_pr__pfet_g5v0d10v5 ad=0.15692 pd=1.305 as=0.0441 ps=0.63 w=0.42 l=0.5
.ends
