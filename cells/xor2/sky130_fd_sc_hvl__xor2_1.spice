* Copyright 2026 FOSSi Foundation
*
* Licensed under the Apache License, Version 2.0 (the "License");
* you may not use this file except in compliance with the License.
* You may obtain a copy of the License at
*
*	https://www.apache.org/licenses/LICENSE-2.0
*
* Unless required by applicable law or agreed to in writing, software
* distributed under the License is distributed on an "AS IS" BASIS,
* WITHOUT WARRANTIES OR CONDITIONS OF ANY KIND, either express or implied.
* See the License for the specific language governing permissions and
* limitations under the License.
*
* SPDX-License-Identifier: Apache-2.0
* NGSPICE file created from sky130_fd_sc_hvl__xor2_1.ext - technology: sky130A

.subckt sky130_fd_sc_hvl__xor2_1 A B VGND VNB VPB VPWR X
X0 a_531_443# a_30_443# X VPB sky130_fd_pr__pfet_g5v0d10v5 ad=0.4275 pd=3.57 as=0.4275 ps=3.57 w=1.5 l=0.5
X1 VPWR B a_531_443# VPB sky130_fd_pr__pfet_g5v0d10v5 ad=0.4275 pd=3.57 as=0.21 ps=1.78 w=1.5 l=0.5
X2 VGND a_30_443# X VNB sky130_fd_pr__nfet_g5v0d10v5 ad=0.21375 pd=2.07 as=0.105 ps=1.03 w=0.75 l=0.5
X3 a_617_107# A VGND VNB sky130_fd_pr__nfet_g5v0d10v5 ad=0.07875 pd=0.96 as=0.32625 ps=1.62 w=0.75 l=0.5
X4 X B a_617_107# VNB sky130_fd_pr__nfet_g5v0d10v5 ad=0.105 pd=1.03 as=0.07875 ps=0.96 w=0.75 l=0.5
X5 a_30_443# B VGND VNB sky130_fd_pr__nfet_g5v0d10v5 ad=0.105 pd=1.03 as=0.21375 ps=2.07 w=0.75 l=0.5
X6 a_531_443# A VPWR VPB sky130_fd_pr__pfet_g5v0d10v5 ad=0.21 pd=1.78 as=0.3825 ps=2.01 w=1.5 l=0.5
X7 VGND A a_30_443# VNB sky130_fd_pr__nfet_g5v0d10v5 ad=0.32625 pd=1.62 as=0.105 ps=1.03 w=0.75 l=0.5
X8 VPWR A a_187_443# VPB sky130_fd_pr__pfet_g5v0d10v5 ad=0.3825 pd=2.01 as=0.1575 ps=1.71 w=1.5 l=0.5
X9 a_187_443# B a_30_443# VPB sky130_fd_pr__pfet_g5v0d10v5 ad=0.1575 pd=1.71 as=0.4275 ps=3.57 w=1.5 l=0.5
.ends
