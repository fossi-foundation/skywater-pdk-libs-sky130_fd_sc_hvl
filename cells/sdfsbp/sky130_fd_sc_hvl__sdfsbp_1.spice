* Copyright 2026 FOSSi Foundation
*
* Licensed under the Apache License, Version 2.0 (the "License");
* you may not use this file except in compliance with the License.
* You may obtain a copy of the License at
*
*	https://www.apache.org/licenses/LICENSE-2.0
*
* Unless required by applicable law or agreed to in writing, software
* distributed under the License is distributed on an "AS IS" BASIS,
* WITHOUT WARRANTIES OR CONDITIONS OF ANY KIND, either express or implied.
* See the License for the specific language governing permissions and
* limitations under the License.
*
* SPDX-License-Identifier: Apache-2.0
* NGSPICE file created from sky130_fd_sc_hvl__sdfsbp_1.ext - technology: sky130A

.subckt sky130_fd_sc_hvl__sdfsbp_1 CLK D SCD SCE SET_B VGND VNB VPB VPWR Q Q_N
X0 VPWR SCE a_30_569# VPB sky130_fd_pr__pfet_g5v0d10v5 ad=0.0588 pd=0.7 as=0.1197 ps=1.41 w=0.42 l=0.5
X1 a_1513_120# a_972_569# a_485_569# VNB sky130_fd_pr__nfet_g5v0d10v5 ad=0.0588 pd=0.7 as=0.1197 ps=1.41 w=0.42 l=0.5
X2 VPWR a_2501_543# a_2729_463# VPB sky130_fd_pr__pfet_g5v0d10v5 ad=0.22185 pd=1.875 as=0.168 ps=1.64 w=0.42 l=0.5
X3 a_2715_173# a_972_569# a_2501_543# VNB sky130_fd_pr__nfet_g5v0d10v5 ad=0.0441 pd=0.63 as=0.12998 ps=1.145 w=0.42 l=0.5
X4 a_2857_173# a_2729_463# a_2715_173# VNB sky130_fd_pr__nfet_g5v0d10v5 ad=0.0441 pd=0.63 as=0.0441 ps=0.63 w=0.42 l=0.5
X5 a_1513_120# a_1243_116# a_485_569# VPB sky130_fd_pr__pfet_g5v0d10v5 ad=0.0588 pd=0.7 as=0.1197 ps=1.41 w=0.42 l=0.5
X6 VGND SET_B a_2857_173# VNB sky130_fd_pr__nfet_g5v0d10v5 ad=0.1197 pd=1.41 as=0.0441 ps=0.63 w=0.42 l=0.5
X7 a_641_569# a_30_569# a_485_569# VPB sky130_fd_pr__pfet_g5v0d10v5 ad=0.0441 pd=0.63 as=0.0588 ps=0.7 w=0.42 l=0.5
X8 VPWR SCD a_641_569# VPB sky130_fd_pr__pfet_g5v0d10v5 ad=0.14048 pd=1.195 as=0.0441 ps=0.63 w=0.42 l=0.5
X9 VGND SCE a_30_569# VNB sky130_fd_pr__nfet_g5v0d10v5 ad=0.0588 pd=0.7 as=0.1197 ps=1.41 w=0.42 l=0.5
X10 a_1243_116# a_972_569# VPWR VPB sky130_fd_pr__pfet_g5v0d10v5 ad=0.19875 pd=2.03 as=0.21375 ps=2.07 w=0.75 l=0.5
X11 a_343_569# SCE VPWR VPB sky130_fd_pr__pfet_g5v0d10v5 ad=0.0441 pd=0.63 as=0.0588 ps=0.7 w=0.42 l=0.5
X12 a_1711_94# a_1513_120# VPWR VPB sky130_fd_pr__pfet_g5v0d10v5 ad=0.0588 pd=0.7 as=0.0756 ps=0.78 w=0.42 l=0.5
X13 a_646_107# SCE a_485_569# VNB sky130_fd_pr__nfet_g5v0d10v5 ad=0.0441 pd=0.63 as=0.0588 ps=0.7 w=0.42 l=0.5
X14 a_485_569# D a_343_569# VPB sky130_fd_pr__pfet_g5v0d10v5 ad=0.0588 pd=0.7 as=0.0441 ps=0.63 w=0.42 l=0.5
X15 VGND SCD a_646_107# VNB sky130_fd_pr__nfet_g5v0d10v5 ad=0.09345 pd=0.865 as=0.0441 ps=0.63 w=0.42 l=0.5
X16 a_1243_116# a_972_569# VGND VNB sky130_fd_pr__nfet_g5v0d10v5 ad=0.1113 pd=1.37 as=0.1113 ps=1.37 w=0.42 l=0.5
X17 a_2394_107# a_1513_120# VGND VNB sky130_fd_pr__nfet_g5v0d10v5 ad=0.07875 pd=0.96 as=0.12247 ps=1.125 w=0.75 l=0.5
X18 a_1669_120# a_1243_116# a_1513_120# VNB sky130_fd_pr__nfet_g5v0d10v5 ad=0.0441 pd=0.63 as=0.0588 ps=0.7 w=0.42 l=0.5
X19 VPWR SET_B a_1711_94# VPB sky130_fd_pr__pfet_g5v0d10v5 ad=0.1656 pd=1.395 as=0.0588 ps=0.7 w=0.42 l=0.5
X20 Q a_3609_173# VPWR VPB sky130_fd_pr__pfet_g5v0d10v5 ad=0.285 pd=2.57 as=0.18375 ps=1.395 w=1 l=0.5
X21 Q_N a_2501_543# VGND VNB sky130_fd_pr__nfet_g5v0d10v5 ad=0.21375 pd=2.07 as=0.12998 ps=1.145 w=0.75 l=0.5
X22 a_2687_543# a_1243_116# a_2501_543# VPB sky130_fd_pr__pfet_g5v0d10v5 ad=0.0441 pd=0.63 as=0.1831 ps=1.43 w=0.42 l=0.5
X23 VGND a_2501_543# a_2729_463# VNB sky130_fd_pr__nfet_g5v0d10v5 ad=0.12998 pd=1.145 as=0.1197 ps=1.41 w=0.42 l=0.5
X24 a_2359_543# a_1513_120# VPWR VPB sky130_fd_pr__pfet_g5v0d10v5 ad=0.105 pd=1.21 as=0.1656 ps=1.395 w=1 l=0.5
X25 a_972_569# CLK VPWR VPB sky130_fd_pr__pfet_g5v0d10v5 ad=0.21375 pd=2.07 as=0.14048 ps=1.195 w=0.75 l=0.5
X26 a_348_107# D VGND VNB sky130_fd_pr__nfet_g5v0d10v5 ad=0.0441 pd=0.63 as=0.0588 ps=0.7 w=0.42 l=0.5
X27 a_485_569# a_30_569# a_348_107# VNB sky130_fd_pr__nfet_g5v0d10v5 ad=0.0588 pd=0.7 as=0.0441 ps=0.63 w=0.42 l=0.5
X28 a_2077_107# a_1513_120# a_1711_94# VNB sky130_fd_pr__nfet_g5v0d10v5 ad=0.0441 pd=0.63 as=0.1113 ps=1.37 w=0.42 l=0.5
X29 VGND a_2501_543# a_3609_173# VNB sky130_fd_pr__nfet_g5v0d10v5 ad=0.12998 pd=1.145 as=0.1197 ps=1.41 w=0.42 l=0.5
X30 VGND SET_B a_2077_107# VNB sky130_fd_pr__nfet_g5v0d10v5 ad=0.12247 pd=1.125 as=0.0441 ps=0.63 w=0.42 l=0.5
X31 VGND a_1711_94# a_1669_120# VNB sky130_fd_pr__nfet_g5v0d10v5 ad=0.1113 pd=1.37 as=0.0441 ps=0.63 w=0.42 l=0.5
X32 a_1710_556# a_972_569# a_1513_120# VPB sky130_fd_pr__pfet_g5v0d10v5 ad=0.0441 pd=0.63 as=0.0588 ps=0.7 w=0.42 l=0.5
X33 a_2501_543# SET_B VPWR VPB sky130_fd_pr__pfet_g5v0d10v5 ad=0.1197 pd=1.41 as=0.0735 ps=0.77 w=0.42 l=0.5
X34 VPWR a_2501_543# a_3609_173# VPB sky130_fd_pr__pfet_g5v0d10v5 ad=0.18375 pd=1.395 as=0.21375 ps=2.07 w=0.75 l=0.5
X35 a_2501_543# a_1243_116# a_2394_107# VNB sky130_fd_pr__nfet_g5v0d10v5 ad=0.12998 pd=1.145 as=0.07875 ps=0.96 w=0.75 l=0.5
X36 VPWR a_1711_94# a_1710_556# VPB sky130_fd_pr__pfet_g5v0d10v5 ad=0.0756 pd=0.78 as=0.0441 ps=0.63 w=0.42 l=0.5
X37 Q_N a_2501_543# VPWR VPB sky130_fd_pr__pfet_g5v0d10v5 ad=0.3975 pd=3.53 as=0.22185 ps=1.875 w=1.5 l=0.5
X38 a_2501_543# a_972_569# a_2359_543# VPB sky130_fd_pr__pfet_g5v0d10v5 ad=0.1831 pd=1.43 as=0.105 ps=1.21 w=1 l=0.5
X39 VPWR a_2729_463# a_2687_543# VPB sky130_fd_pr__pfet_g5v0d10v5 ad=0.0735 pd=0.77 as=0.0441 ps=0.63 w=0.42 l=0.5
X40 a_972_569# CLK VGND VNB sky130_fd_pr__nfet_g5v0d10v5 ad=0.1113 pd=1.37 as=0.09345 ps=0.865 w=0.42 l=0.5
X41 Q a_3609_173# VGND VNB sky130_fd_pr__nfet_g5v0d10v5 ad=0.21375 pd=2.07 as=0.12998 ps=1.145 w=0.75 l=0.5
.ends
