* Copyright 2026 FOSSi Foundation
*
* Licensed under the Apache License, Version 2.0 (the "License");
* you may not use this file except in compliance with the License.
* You may obtain a copy of the License at
*
*	https://www.apache.org/licenses/LICENSE-2.0
*
* Unless required by applicable law or agreed to in writing, software
* distributed under the License is distributed on an "AS IS" BASIS,
* WITHOUT WARRANTIES OR CONDITIONS OF ANY KIND, either express or implied.
* See the License for the specific language governing permissions and
* limitations under the License.
*
* SPDX-License-Identifier: Apache-2.0
* NGSPICE file created from sky130_fd_sc_hvl__dfxtp_1.ext - technology: sky130A

.subckt sky130_fd_sc_hvl__dfxtp_1 CLK D VGND VNB VPB VPWR Q
X0 a_982_543# a_30_127# a_780_574# VPB sky130_fd_pr__pfet_g5v0d10v5 ad=0.0441 pd=0.63 as=0.12957 ps=1.085 w=0.42 l=0.5
X1 a_1687_113# a_30_127# a_1455_543# VNB sky130_fd_pr__nfet_g5v0d10v5 ad=0.0441 pd=0.63 as=0.0588 ps=0.7 w=0.42 l=0.5
X2 a_339_559# a_30_127# VPWR VPB sky130_fd_pr__pfet_g5v0d10v5 ad=0.19875 pd=2.03 as=0.105 ps=1.03 w=0.75 l=0.5
X3 a_1015_113# a_339_559# a_780_574# VNB sky130_fd_pr__nfet_g5v0d10v5 ad=0.0441 pd=0.63 as=0.09975 ps=0.895 w=0.42 l=0.5
X4 a_1024_371# a_780_574# VPWR VPB sky130_fd_pr__pfet_g5v0d10v5 ad=0.14 pd=1.28 as=0.1556 ps=1.375 w=1 l=0.5
X5 a_339_559# a_30_127# VGND VNB sky130_fd_pr__nfet_g5v0d10v5 ad=0.1197 pd=1.41 as=0.0588 ps=0.7 w=0.42 l=0.5
X6 VGND a_1024_371# a_1015_113# VNB sky130_fd_pr__nfet_g5v0d10v5 ad=0.15998 pd=1.225 as=0.0441 ps=0.63 w=0.42 l=0.5
X7 VGND a_1729_87# a_1687_113# VNB sky130_fd_pr__nfet_g5v0d10v5 ad=0.16132 pd=1.31 as=0.0441 ps=0.63 w=0.42 l=0.5
X8 VPWR a_1024_371# a_982_543# VPB sky130_fd_pr__pfet_g5v0d10v5 ad=0.1556 pd=1.375 as=0.0441 ps=0.63 w=0.42 l=0.5
X9 a_1455_543# a_339_559# a_1024_371# VNB sky130_fd_pr__nfet_g5v0d10v5 ad=0.0588 pd=0.7 as=0.12998 ps=1.145 w=0.42 l=0.5
X10 a_780_574# a_30_127# a_605_563# VNB sky130_fd_pr__nfet_g5v0d10v5 ad=0.09975 pd=0.895 as=0.084 ps=0.82 w=0.42 l=0.5
X11 Q a_1729_87# VPWR VPB sky130_fd_pr__pfet_g5v0d10v5 ad=0.3975 pd=3.53 as=0.3975 ps=3.53 w=1.5 l=0.5
X12 VPWR CLK a_30_127# VPB sky130_fd_pr__pfet_g5v0d10v5 ad=0.105 pd=1.03 as=0.19875 ps=2.03 w=0.75 l=0.5
X13 a_780_574# a_339_559# a_605_563# VPB sky130_fd_pr__pfet_g5v0d10v5 ad=0.12957 pd=1.085 as=0.0826 ps=0.85 w=0.42 l=0.5
X14 a_605_563# D VGND VNB sky130_fd_pr__nfet_g5v0d10v5 ad=0.084 pd=0.82 as=0.1197 ps=1.41 w=0.42 l=0.5
X15 a_1731_543# a_339_559# a_1455_543# VPB sky130_fd_pr__pfet_g5v0d10v5 ad=0.0441 pd=0.63 as=0.4081 ps=1.88 w=0.42 l=0.5
X16 a_1024_371# a_780_574# VGND VNB sky130_fd_pr__nfet_g5v0d10v5 ad=0.12998 pd=1.145 as=0.15998 ps=1.225 w=0.75 l=0.5
X17 a_1729_87# a_1455_543# VGND VNB sky130_fd_pr__nfet_g5v0d10v5 ad=0.21375 pd=2.07 as=0.16132 ps=1.31 w=0.75 l=0.5
X18 VPWR a_1729_87# a_1731_543# VPB sky130_fd_pr__pfet_g5v0d10v5 ad=0.1556 pd=1.375 as=0.0441 ps=0.63 w=0.42 l=0.5
X19 VGND CLK a_30_127# VNB sky130_fd_pr__nfet_g5v0d10v5 ad=0.0588 pd=0.7 as=0.1197 ps=1.41 w=0.42 l=0.5
X20 Q a_1729_87# VGND VNB sky130_fd_pr__nfet_g5v0d10v5 ad=0.19875 pd=2.03 as=0.21375 ps=2.07 w=0.75 l=0.5
X21 a_605_563# D VPWR VPB sky130_fd_pr__pfet_g5v0d10v5 ad=0.0826 pd=0.85 as=0.1113 ps=1.37 w=0.42 l=0.5
X22 a_1729_87# a_1455_543# VPWR VPB sky130_fd_pr__pfet_g5v0d10v5 ad=0.265 pd=2.53 as=0.1556 ps=1.375 w=1 l=0.5
X23 a_1455_543# a_30_127# a_1024_371# VPB sky130_fd_pr__pfet_g5v0d10v5 ad=0.4081 pd=1.88 as=0.14 ps=1.28 w=1 l=0.5
.ends
