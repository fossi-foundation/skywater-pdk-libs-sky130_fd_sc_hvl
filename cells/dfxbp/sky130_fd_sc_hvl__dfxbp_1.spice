* Copyright 2026 FOSSi Foundation
*
* Licensed under the Apache License, Version 2.0 (the "License");
* you may not use this file except in compliance with the License.
* You may obtain a copy of the License at
*
*	https://www.apache.org/licenses/LICENSE-2.0
*
* Unless required by applicable law or agreed to in writing, software
* distributed under the License is distributed on an "AS IS" BASIS,
* WITHOUT WARRANTIES OR CONDITIONS OF ANY KIND, either express or implied.
* See the License for the specific language governing permissions and
* limitations under the License.
*
* SPDX-License-Identifier: Apache-2.0
* NGSPICE file created from sky130_fd_sc_hvl__dfxbp_1.ext - technology: sky130A

.subckt sky130_fd_sc_hvl__dfxbp_1 CLK D VGND VNB VPB VPWR Q Q_N
X0 a_1494_539# a_30_112# a_1063_85# VPB sky130_fd_pr__pfet_g5v0d10v5 ad=0.1556 pd=1.375 as=0.14 ps=1.28 w=1 l=0.5
X1 VPWR a_1711_85# Q VPB sky130_fd_pr__pfet_g5v0d10v5 ad=0.3975 pd=3.53 as=0.3975 ps=3.53 w=1.5 l=0.5
X2 a_1669_539# a_339_112# a_1494_539# VPB sky130_fd_pr__pfet_g5v0d10v5 ad=0.0441 pd=0.63 as=0.1556 ps=1.375 w=0.42 l=0.5
X3 a_339_112# a_30_112# VGND VNB sky130_fd_pr__nfet_g5v0d10v5 ad=0.1197 pd=1.41 as=0.0588 ps=0.7 w=0.42 l=0.5
X4 a_1711_85# a_1494_539# VPWR VPB sky130_fd_pr__pfet_g5v0d10v5 ad=0.265 pd=2.53 as=0.1556 ps=1.375 w=1 l=0.5
X5 a_1669_111# a_30_112# a_1494_539# VNB sky130_fd_pr__nfet_g5v0d10v5 ad=0.0441 pd=0.63 as=0.0588 ps=0.7 w=0.42 l=0.5
X6 VPWR a_1711_85# a_2365_443# VPB sky130_fd_pr__pfet_g5v0d10v5 ad=0.255 pd=1.895 as=0.19875 ps=2.03 w=0.75 l=0.5
X7 a_709_111# D VPWR VPB sky130_fd_pr__pfet_g5v0d10v5 ad=0.0588 pd=0.7 as=0.1197 ps=1.41 w=0.42 l=0.5
X8 a_1711_85# a_1494_539# VGND VNB sky130_fd_pr__nfet_g5v0d10v5 ad=0.19875 pd=2.03 as=0.12247 ps=1.125 w=0.75 l=0.5
X9 VGND a_1711_85# Q VNB sky130_fd_pr__nfet_g5v0d10v5 ad=0.21375 pd=2.07 as=0.19875 ps=2.03 w=0.75 l=0.5
X10 VPWR a_1711_85# a_1669_539# VPB sky130_fd_pr__pfet_g5v0d10v5 ad=0.1556 pd=1.375 as=0.0441 ps=0.63 w=0.42 l=0.5
X11 a_709_111# D VGND VNB sky130_fd_pr__nfet_g5v0d10v5 ad=0.0588 pd=0.7 as=0.1533 ps=1.57 w=0.42 l=0.5
X12 VGND a_1711_85# a_2365_443# VNB sky130_fd_pr__nfet_g5v0d10v5 ad=0.12998 pd=1.145 as=0.1113 ps=1.37 w=0.42 l=0.5
X13 a_1021_539# a_30_112# a_865_111# VPB sky130_fd_pr__pfet_g5v0d10v5 ad=0.0441 pd=0.63 as=0.0588 ps=0.7 w=0.42 l=0.5
X14 VPWR CLK a_30_112# VPB sky130_fd_pr__pfet_g5v0d10v5 ad=0.105 pd=1.03 as=0.21375 ps=2.07 w=0.75 l=0.5
X15 VGND a_1711_85# a_1669_111# VNB sky130_fd_pr__nfet_g5v0d10v5 ad=0.12247 pd=1.125 as=0.0441 ps=0.63 w=0.42 l=0.5
X16 a_1021_111# a_339_112# a_865_111# VNB sky130_fd_pr__nfet_g5v0d10v5 ad=0.0441 pd=0.63 as=0.0588 ps=0.7 w=0.42 l=0.5
X17 VPWR a_1063_85# a_1021_539# VPB sky130_fd_pr__pfet_g5v0d10v5 ad=0.1556 pd=1.375 as=0.0441 ps=0.63 w=0.42 l=0.5
X18 a_1063_85# a_865_111# VPWR VPB sky130_fd_pr__pfet_g5v0d10v5 ad=0.14 pd=1.28 as=0.1556 ps=1.375 w=1 l=0.5
X19 VGND a_1063_85# a_1021_111# VNB sky130_fd_pr__nfet_g5v0d10v5 ad=0.12247 pd=1.125 as=0.0441 ps=0.63 w=0.42 l=0.5
X20 a_865_111# a_339_112# a_709_111# VPB sky130_fd_pr__pfet_g5v0d10v5 ad=0.0588 pd=0.7 as=0.0588 ps=0.7 w=0.42 l=0.5
X21 Q_N a_2365_443# VPWR VPB sky130_fd_pr__pfet_g5v0d10v5 ad=0.4275 pd=3.57 as=0.255 ps=1.895 w=1.5 l=0.5
X22 a_1063_85# a_865_111# VGND VNB sky130_fd_pr__nfet_g5v0d10v5 ad=0.12247 pd=1.125 as=0.12247 ps=1.125 w=0.75 l=0.5
X23 VGND CLK a_30_112# VNB sky130_fd_pr__nfet_g5v0d10v5 ad=0.0588 pd=0.7 as=0.1113 ps=1.37 w=0.42 l=0.5
X24 a_1494_539# a_339_112# a_1063_85# VNB sky130_fd_pr__nfet_g5v0d10v5 ad=0.0588 pd=0.7 as=0.12247 ps=1.125 w=0.42 l=0.5
X25 a_339_112# a_30_112# VPWR VPB sky130_fd_pr__pfet_g5v0d10v5 ad=0.21375 pd=2.07 as=0.105 ps=1.03 w=0.75 l=0.5
X26 a_865_111# a_30_112# a_709_111# VNB sky130_fd_pr__nfet_g5v0d10v5 ad=0.0588 pd=0.7 as=0.0588 ps=0.7 w=0.42 l=0.5
X27 Q_N a_2365_443# VGND VNB sky130_fd_pr__nfet_g5v0d10v5 ad=0.19875 pd=2.03 as=0.12998 ps=1.145 w=0.75 l=0.5
.ends
