* Copyright 2026 FOSSi Foundation
*
* Licensed under the Apache License, Version 2.0 (the "License");
* you may not use this file except in compliance with the License.
* You may obtain a copy of the License at
*
*	https://www.apache.org/licenses/LICENSE-2.0
*
* Unless required by applicable law or agreed to in writing, software
* distributed under the License is distributed on an "AS IS" BASIS,
* WITHOUT WARRANTIES OR CONDITIONS OF ANY KIND, either express or implied.
* See the License for the specific language governing permissions and
* limitations under the License.
*
* SPDX-License-Identifier: Apache-2.0
* NGSPICE file created from sky130_fd_sc_hvl__o22a_1.ext - technology: sky130A

.subckt sky130_fd_sc_hvl__o22a_1 A1 A2 B1 B2 VGND VNB VPB VPWR X
X0 a_87_81# B2 a_533_443# VPB sky130_fd_pr__pfet_g5v0d10v5 ad=0.21 pd=1.78 as=0.1575 ps=1.71 w=1.5 l=0.5
X1 VGND A2 a_354_107# VNB sky130_fd_pr__nfet_g5v0d10v5 ad=0.21375 pd=2.07 as=0.105 ps=1.03 w=0.75 l=0.5
X2 VGND a_87_81# X VNB sky130_fd_pr__nfet_g5v0d10v5 ad=0.12562 pd=1.085 as=0.21375 ps=2.07 w=0.75 l=0.5
X3 a_87_81# B1 a_354_107# VNB sky130_fd_pr__nfet_g5v0d10v5 ad=0.12188 pd=1.075 as=0.105 ps=1.03 w=0.75 l=0.5
X4 a_354_107# B2 a_87_81# VNB sky130_fd_pr__nfet_g5v0d10v5 ad=0.105 pd=1.03 as=0.12188 ps=1.075 w=0.75 l=0.5
X5 a_831_443# A2 a_87_81# VPB sky130_fd_pr__pfet_g5v0d10v5 ad=0.1575 pd=1.71 as=0.21 ps=1.78 w=1.5 l=0.5
X6 a_354_107# A1 VGND VNB sky130_fd_pr__nfet_g5v0d10v5 ad=0.105 pd=1.03 as=0.12562 ps=1.085 w=0.75 l=0.5
X7 VPWR A1 a_831_443# VPB sky130_fd_pr__pfet_g5v0d10v5 ad=0.3975 pd=3.53 as=0.1575 ps=1.71 w=1.5 l=0.5
X8 VPWR a_87_81# X VPB sky130_fd_pr__pfet_g5v0d10v5 ad=0.9225 pd=2.73 as=0.4275 ps=3.57 w=1.5 l=0.5
X9 a_533_443# B1 VPWR VPB sky130_fd_pr__pfet_g5v0d10v5 ad=0.1575 pd=1.71 as=0.9225 ps=2.73 w=1.5 l=0.5
.ends
