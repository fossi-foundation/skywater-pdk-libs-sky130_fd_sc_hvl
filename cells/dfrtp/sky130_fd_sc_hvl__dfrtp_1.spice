* Copyright 2026 FOSSi Foundation
*
* Licensed under the Apache License, Version 2.0 (the "License");
* you may not use this file except in compliance with the License.
* You may obtain a copy of the License at
*
*	https://www.apache.org/licenses/LICENSE-2.0
*
* Unless required by applicable law or agreed to in writing, software
* distributed under the License is distributed on an "AS IS" BASIS,
* WITHOUT WARRANTIES OR CONDITIONS OF ANY KIND, either express or implied.
* See the License for the specific language governing permissions and
* limitations under the License.
*
* SPDX-License-Identifier: Apache-2.0
* NGSPICE file created from sky130_fd_sc_hvl__dfrtp_1.ext - technology: sky130A

.subckt sky130_fd_sc_hvl__dfrtp_1 CLK D RESET_B VGND VNB VPB VPWR Q
X0 a_339_537# a_30_107# VPWR VPB sky130_fd_pr__pfet_g5v0d10v5 ad=0.19875 pd=2.03 as=0.105 ps=1.03 w=0.75 l=0.5
X1 a_921_632# a_339_537# a_452_632# VPB sky130_fd_pr__pfet_g5v0d10v5 ad=0.0588 pd=0.7 as=0.0588 ps=0.7 w=0.42 l=0.5
X2 a_2096_417# RESET_B VPWR VPB sky130_fd_pr__pfet_g5v0d10v5 ad=0.0588 pd=0.7 as=0.08085 ps=0.805 w=0.42 l=0.5
X3 a_921_632# a_30_107# a_452_632# VNB sky130_fd_pr__nfet_g5v0d10v5 ad=0.0588 pd=0.7 as=0.0588 ps=0.7 w=0.42 l=0.5
X4 a_921_632# RESET_B VPWR VPB sky130_fd_pr__pfet_g5v0d10v5 ad=0.1197 pd=1.41 as=0.0756 ps=0.78 w=0.42 l=0.5
X5 a_1875_543# a_30_107# a_1119_506# VPB sky130_fd_pr__pfet_g5v0d10v5 ad=0.1656 pd=1.395 as=0.14 ps=1.28 w=1 l=0.5
X6 a_452_632# D VPWR VPB sky130_fd_pr__pfet_g5v0d10v5 ad=0.0588 pd=0.7 as=0.0588 ps=0.7 w=0.42 l=0.5
X7 a_637_173# RESET_B VGND VNB sky130_fd_pr__nfet_g5v0d10v5 ad=0.0441 pd=0.63 as=0.1197 ps=1.41 w=0.42 l=0.5
X8 a_2387_107# RESET_B VGND VNB sky130_fd_pr__nfet_g5v0d10v5 ad=0.0441 pd=0.63 as=0.0588 ps=0.7 w=0.42 l=0.5
X9 a_452_632# D a_637_173# VNB sky130_fd_pr__nfet_g5v0d10v5 ad=0.0588 pd=0.7 as=0.0441 ps=0.63 w=0.42 l=0.5
X10 Q a_2649_207# VPWR VPB sky130_fd_pr__pfet_g5v0d10v5 ad=0.3975 pd=3.53 as=0.24 ps=1.875 w=1.5 l=0.5
X11 VGND a_1875_543# a_2649_207# VNB sky130_fd_pr__nfet_g5v0d10v5 ad=0.12998 pd=1.145 as=0.1197 ps=1.41 w=0.42 l=0.5
X12 VGND CLK a_30_107# VNB sky130_fd_pr__nfet_g5v0d10v5 ad=0.0588 pd=0.7 as=0.1197 ps=1.41 w=0.42 l=0.5
X13 a_1875_543# a_339_537# a_1119_506# VNB sky130_fd_pr__nfet_g5v0d10v5 ad=0.15368 pd=1.25 as=0.105 ps=1.03 w=0.75 l=0.5
X14 a_1077_632# a_30_107# a_921_632# VPB sky130_fd_pr__pfet_g5v0d10v5 ad=0.0441 pd=0.63 as=0.0588 ps=0.7 w=0.42 l=0.5
X15 a_1091_173# a_339_537# a_921_632# VNB sky130_fd_pr__nfet_g5v0d10v5 ad=0.0441 pd=0.63 as=0.0588 ps=0.7 w=0.42 l=0.5
X16 VPWR CLK a_30_107# VPB sky130_fd_pr__pfet_g5v0d10v5 ad=0.105 pd=1.03 as=0.19875 ps=2.03 w=0.75 l=0.5
X17 VPWR a_1875_543# a_2649_207# VPB sky130_fd_pr__pfet_g5v0d10v5 ad=0.24 pd=1.875 as=0.21375 ps=2.07 w=0.75 l=0.5
X18 a_2096_417# a_1875_543# a_2387_107# VNB sky130_fd_pr__nfet_g5v0d10v5 ad=0.1197 pd=1.41 as=0.0441 ps=0.63 w=0.42 l=0.5
X19 VPWR a_2096_417# a_2054_543# VPB sky130_fd_pr__pfet_g5v0d10v5 ad=0.08085 pd=0.805 as=0.0441 ps=0.63 w=0.42 l=0.5
X20 a_1119_506# a_921_632# VPWR VPB sky130_fd_pr__pfet_g5v0d10v5 ad=0.14 pd=1.28 as=0.285 ps=2.57 w=1 l=0.5
X21 a_339_537# a_30_107# VGND VNB sky130_fd_pr__nfet_g5v0d10v5 ad=0.1197 pd=1.41 as=0.0588 ps=0.7 w=0.42 l=0.5
X22 VGND RESET_B a_1233_173# VNB sky130_fd_pr__nfet_g5v0d10v5 ad=0.32588 pd=2.015 as=0.04935 ps=0.655 w=0.42 l=0.5
X23 VPWR RESET_B a_452_632# VPB sky130_fd_pr__pfet_g5v0d10v5 ad=0.0588 pd=0.7 as=0.1197 ps=1.41 w=0.42 l=0.5
X24 VPWR a_1875_543# a_2096_417# VPB sky130_fd_pr__pfet_g5v0d10v5 ad=0.1197 pd=1.41 as=0.0588 ps=0.7 w=0.42 l=0.5
X25 a_2089_107# a_30_107# a_1875_543# VNB sky130_fd_pr__nfet_g5v0d10v5 ad=0.0441 pd=0.63 as=0.15368 ps=1.25 w=0.42 l=0.5
X26 VGND a_2096_417# a_2089_107# VNB sky130_fd_pr__nfet_g5v0d10v5 ad=0.0588 pd=0.7 as=0.0441 ps=0.63 w=0.42 l=0.5
X27 VPWR a_1119_506# a_1077_632# VPB sky130_fd_pr__pfet_g5v0d10v5 ad=0.0756 pd=0.78 as=0.0441 ps=0.63 w=0.42 l=0.5
X28 a_2054_543# a_339_537# a_1875_543# VPB sky130_fd_pr__pfet_g5v0d10v5 ad=0.0441 pd=0.63 as=0.1656 ps=1.395 w=0.42 l=0.5
X29 Q a_2649_207# VGND VNB sky130_fd_pr__nfet_g5v0d10v5 ad=0.21375 pd=2.07 as=0.12998 ps=1.145 w=0.75 l=0.5
X30 a_1233_173# a_1119_506# a_1091_173# VNB sky130_fd_pr__nfet_g5v0d10v5 ad=0.04935 pd=0.655 as=0.0441 ps=0.63 w=0.42 l=0.5
X31 a_1119_506# a_921_632# VGND VNB sky130_fd_pr__nfet_g5v0d10v5 ad=0.105 pd=1.03 as=0.32588 ps=2.015 w=0.75 l=0.5
.ends
