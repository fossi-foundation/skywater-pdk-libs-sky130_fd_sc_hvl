* Copyright 2026 FOSSi Foundation
*
* Licensed under the Apache License, Version 2.0 (the "License");
* you may not use this file except in compliance with the License.
* You may obtain a copy of the License at
*
*	https://www.apache.org/licenses/LICENSE-2.0
*
* Unless required by applicable law or agreed to in writing, software
* distributed under the License is distributed on an "AS IS" BASIS,
* WITHOUT WARRANTIES OR CONDITIONS OF ANY KIND, either express or implied.
* See the License for the specific language governing permissions and
* limitations under the License.
*
* SPDX-License-Identifier: Apache-2.0
* NGSPICE file created from sky130_fd_sc_hvl__einvn_1.ext - technology: sky130A

.subckt sky130_fd_sc_hvl__einvn_1 A TE_B VGND VNB VPB VPWR Z
X0 Z A a_413_443# VPB sky130_fd_pr__pfet_g5v0d10v5 ad=0.4275 pd=3.57 as=0.2475 ps=1.83 w=1.5 l=0.5
X1 VGND TE_B a_30_173# VNB sky130_fd_pr__nfet_g5v0d10v5 ad=0.26482 pd=1.52 as=0.1113 ps=1.37 w=0.42 l=0.5
X2 a_437_107# a_30_173# VGND VNB sky130_fd_pr__nfet_g5v0d10v5 ad=0.07875 pd=0.96 as=0.26482 ps=1.52 w=0.75 l=0.5
X3 Z A a_437_107# VNB sky130_fd_pr__nfet_g5v0d10v5 ad=0.21375 pd=2.07 as=0.07875 ps=0.96 w=0.75 l=0.5
X4 a_413_443# TE_B VPWR VPB sky130_fd_pr__pfet_g5v0d10v5 ad=0.2475 pd=1.83 as=0.3329 ps=2.055 w=1.5 l=0.5
X5 VPWR TE_B a_30_173# VPB sky130_fd_pr__pfet_g5v0d10v5 ad=0.3329 pd=2.055 as=0.21375 ps=2.07 w=0.75 l=0.5
.ends
