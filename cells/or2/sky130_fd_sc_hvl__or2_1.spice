* Copyright 2026 FOSSi Foundation
*
* Licensed under the Apache License, Version 2.0 (the "License");
* you may not use this file except in compliance with the License.
* You may obtain a copy of the License at
*
*	https://www.apache.org/licenses/LICENSE-2.0
*
* Unless required by applicable law or agreed to in writing, software
* distributed under the License is distributed on an "AS IS" BASIS,
* WITHOUT WARRANTIES OR CONDITIONS OF ANY KIND, either express or implied.
* See the License for the specific language governing permissions and
* limitations under the License.
*
* SPDX-License-Identifier: Apache-2.0
* NGSPICE file created from sky130_fd_sc_hvl__or2_1.ext - technology: sky130A

.subckt sky130_fd_sc_hvl__or2_1 A B VGND VNB VPB VPWR X
X0 X a_84_443# VPWR VPB sky130_fd_pr__pfet_g5v0d10v5 ad=0.4275 pd=3.57 as=0.261 ps=2.01 w=1.5 l=0.5
X1 VGND A a_84_443# VNB sky130_fd_pr__nfet_g5v0d10v5 ad=0.13942 pd=1.19 as=0.0588 ps=0.7 w=0.42 l=0.5
X2 a_241_443# B a_84_443# VPB sky130_fd_pr__pfet_g5v0d10v5 ad=0.0441 pd=0.63 as=0.1197 ps=1.41 w=0.42 l=0.5
X3 VPWR A a_241_443# VPB sky130_fd_pr__pfet_g5v0d10v5 ad=0.261 pd=2.01 as=0.0441 ps=0.63 w=0.42 l=0.5
X4 X a_84_443# VGND VNB sky130_fd_pr__nfet_g5v0d10v5 ad=0.21375 pd=2.07 as=0.13942 ps=1.19 w=0.75 l=0.5
X5 a_84_443# B VGND VNB sky130_fd_pr__nfet_g5v0d10v5 ad=0.0588 pd=0.7 as=0.1197 ps=1.41 w=0.42 l=0.5
.ends
