* Copyright 2026 FOSSi Foundation
*
* Licensed under the Apache License, Version 2.0 (the "License");
* you may not use this file except in compliance with the License.
* You may obtain a copy of the License at
*
*	https://www.apache.org/licenses/LICENSE-2.0
*
* Unless required by applicable law or agreed to in writing, software
* distributed under the License is distributed on an "AS IS" BASIS,
* WITHOUT WARRANTIES OR CONDITIONS OF ANY KIND, either express or implied.
* See the License for the specific language governing permissions and
* limitations under the License.
*
* SPDX-License-Identifier: Apache-2.0
* NGSPICE file created from sky130_fd_sc_hvl__dfrbp_1.ext - technology: sky130A

.subckt sky130_fd_sc_hvl__dfrbp_1 CLK D RESET_B VGND VNB VPB VPWR Q Q_N
X0 a_350_107# a_37_107# VGND VNB sky130_fd_pr__nfet_g5v0d10v5 ad=0.1197 pd=1.41 as=0.0588 ps=0.7 w=0.42 l=0.5
X1 a_1900_107# a_37_107# a_1176_466# VPB sky130_fd_pr__pfet_g5v0d10v5 ad=0.1656 pd=1.395 as=0.14 ps=1.28 w=1 l=0.5
X2 VPWR CLK a_37_107# VPB sky130_fd_pr__pfet_g5v0d10v5 ad=0.18375 pd=1.24 as=0.21375 ps=2.07 w=0.75 l=0.5
X3 a_2114_107# a_37_107# a_1900_107# VNB sky130_fd_pr__nfet_g5v0d10v5 ad=0.0441 pd=0.63 as=0.16095 ps=1.32 w=0.42 l=0.5
X4 VGND a_2122_348# a_2114_107# VNB sky130_fd_pr__nfet_g5v0d10v5 ad=0.0588 pd=0.7 as=0.0441 ps=0.63 w=0.42 l=0.5
X5 a_978_608# a_37_107# a_509_608# VNB sky130_fd_pr__nfet_g5v0d10v5 ad=0.09345 pd=0.865 as=0.0588 ps=0.7 w=0.42 l=0.5
X6 a_509_608# D VPWR VPB sky130_fd_pr__pfet_g5v0d10v5 ad=0.0588 pd=0.7 as=0.0588 ps=0.7 w=0.42 l=0.5
X7 a_1176_466# a_978_608# VPWR VPB sky130_fd_pr__pfet_g5v0d10v5 ad=0.14 pd=1.28 as=0.285 ps=2.57 w=1 l=0.5
X8 Q a_2937_443# VPWR VPB sky130_fd_pr__pfet_g5v0d10v5 ad=0.4275 pd=3.57 as=0.255 ps=1.895 w=1.5 l=0.5
X9 a_509_608# D a_728_173# VNB sky130_fd_pr__nfet_g5v0d10v5 ad=0.0588 pd=0.7 as=0.0441 ps=0.63 w=0.42 l=0.5
X10 a_978_608# RESET_B VPWR VPB sky130_fd_pr__pfet_g5v0d10v5 ad=0.1197 pd=1.41 as=0.0588 ps=0.7 w=0.42 l=0.5
X11 a_728_173# RESET_B VGND VNB sky130_fd_pr__nfet_g5v0d10v5 ad=0.0441 pd=0.63 as=0.1197 ps=1.41 w=0.42 l=0.5
X12 VPWR a_1900_107# a_2122_348# VPB sky130_fd_pr__pfet_g5v0d10v5 ad=0.32295 pd=2.305 as=0.0588 ps=0.7 w=0.42 l=0.5
X13 a_1900_107# a_350_107# a_1176_466# VNB sky130_fd_pr__nfet_g5v0d10v5 ad=0.16095 pd=1.32 as=0.105 ps=1.03 w=0.75 l=0.5
X14 Q_N a_1900_107# VGND VNB sky130_fd_pr__nfet_g5v0d10v5 ad=0.21375 pd=2.07 as=0.21375 ps=2.07 w=0.75 l=0.5
X15 a_2079_462# a_350_107# a_1900_107# VPB sky130_fd_pr__pfet_g5v0d10v5 ad=0.04515 pd=0.635 as=0.1656 ps=1.395 w=0.42 l=0.5
X16 VGND CLK a_37_107# VNB sky130_fd_pr__nfet_g5v0d10v5 ad=0.0588 pd=0.7 as=0.1197 ps=1.41 w=0.42 l=0.5
X17 VGND a_1900_107# a_2937_443# VNB sky130_fd_pr__nfet_g5v0d10v5 ad=0.12998 pd=1.145 as=0.1197 ps=1.41 w=0.42 l=0.5
X18 Q a_2937_443# VGND VNB sky130_fd_pr__nfet_g5v0d10v5 ad=0.19875 pd=2.03 as=0.12998 ps=1.145 w=0.75 l=0.5
X19 VPWR RESET_B a_509_608# VPB sky130_fd_pr__pfet_g5v0d10v5 ad=0.0588 pd=0.7 as=0.1197 ps=1.41 w=0.42 l=0.5
X20 a_1134_608# a_37_107# a_978_608# VPB sky130_fd_pr__pfet_g5v0d10v5 ad=0.0441 pd=0.63 as=0.0588 ps=0.7 w=0.42 l=0.5
X21 VPWR a_1176_466# a_1134_608# VPB sky130_fd_pr__pfet_g5v0d10v5 ad=0.0588 pd=0.7 as=0.0441 ps=0.63 w=0.42 l=0.5
X22 Q_N a_1900_107# VPWR VPB sky130_fd_pr__pfet_g5v0d10v5 ad=0.4275 pd=3.57 as=0.32295 ps=2.305 w=1.5 l=0.5
X23 a_2122_348# RESET_B VPWR VPB sky130_fd_pr__pfet_g5v0d10v5 ad=0.0588 pd=0.7 as=0.0798 ps=0.8 w=0.42 l=0.5
X24 a_1215_173# a_350_107# a_978_608# VNB sky130_fd_pr__nfet_g5v0d10v5 ad=0.0441 pd=0.63 as=0.09345 ps=0.865 w=0.42 l=0.5
X25 VGND RESET_B a_1357_173# VNB sky130_fd_pr__nfet_g5v0d10v5 ad=0.20828 pd=1.455 as=0.0483 ps=0.65 w=0.42 l=0.5
X26 a_350_107# a_37_107# VPWR VPB sky130_fd_pr__pfet_g5v0d10v5 ad=0.21375 pd=2.07 as=0.18375 ps=1.24 w=0.75 l=0.5
X27 VPWR a_2122_348# a_2079_462# VPB sky130_fd_pr__pfet_g5v0d10v5 ad=0.0798 pd=0.8 as=0.04515 ps=0.635 w=0.42 l=0.5
X28 a_1357_173# a_1176_466# a_1215_173# VNB sky130_fd_pr__nfet_g5v0d10v5 ad=0.0483 pd=0.65 as=0.0441 ps=0.63 w=0.42 l=0.5
X29 a_1176_466# a_978_608# VGND VNB sky130_fd_pr__nfet_g5v0d10v5 ad=0.105 pd=1.03 as=0.20828 ps=1.455 w=0.75 l=0.5
X30 a_978_608# a_350_107# a_509_608# VPB sky130_fd_pr__pfet_g5v0d10v5 ad=0.0588 pd=0.7 as=0.0588 ps=0.7 w=0.42 l=0.5
X31 a_2412_107# RESET_B VGND VNB sky130_fd_pr__nfet_g5v0d10v5 ad=0.0441 pd=0.63 as=0.0588 ps=0.7 w=0.42 l=0.5
X32 VPWR a_1900_107# a_2937_443# VPB sky130_fd_pr__pfet_g5v0d10v5 ad=0.255 pd=1.895 as=0.21375 ps=2.07 w=0.75 l=0.5
X33 a_2122_348# a_1900_107# a_2412_107# VNB sky130_fd_pr__nfet_g5v0d10v5 ad=0.1113 pd=1.37 as=0.0441 ps=0.63 w=0.42 l=0.5
.ends
