* Copyright 2026 FOSSi Foundation
*
* Licensed under the Apache License, Version 2.0 (the "License");
* you may not use this file except in compliance with the License.
* You may obtain a copy of the License at
*
*	https://www.apache.org/licenses/LICENSE-2.0
*
* Unless required by applicable law or agreed to in writing, software
* distributed under the License is distributed on an "AS IS" BASIS,
* WITHOUT WARRANTIES OR CONDITIONS OF ANY KIND, either express or implied.
* See the License for the specific language governing permissions and
* limitations under the License.
*
* SPDX-License-Identifier: Apache-2.0
* NGSPICE file created from sky130_fd_sc_hvl__a22o_1.ext - technology: sky130A

.subckt sky130_fd_sc_hvl__a22o_1 A1 A2 B1 B2 VGND VNB VPB VPWR X
X0 a_519_107# B2 VGND VNB sky130_fd_pr__nfet_g5v0d10v5 ad=0.07875 pd=0.96 as=0.4425 ps=1.93 w=0.75 l=0.5
X1 a_83_81# B1 a_519_107# VNB sky130_fd_pr__nfet_g5v0d10v5 ad=0.11438 pd=1.055 as=0.07875 ps=0.96 w=0.75 l=0.5
X2 a_83_81# B2 a_316_443# VPB sky130_fd_pr__pfet_g5v0d10v5 ad=0.21 pd=1.78 as=0.6675 ps=3.89 w=1.5 l=0.5
X3 VPWR A1 a_316_443# VPB sky130_fd_pr__pfet_g5v0d10v5 ad=0.21 pd=1.78 as=0.21 ps=1.78 w=1.5 l=0.5
X4 a_316_443# B1 a_83_81# VPB sky130_fd_pr__pfet_g5v0d10v5 ad=0.21 pd=1.78 as=0.21 ps=1.78 w=1.5 l=0.5
X5 a_822_107# A1 a_83_81# VNB sky130_fd_pr__nfet_g5v0d10v5 ad=0.07875 pd=0.96 as=0.11438 ps=1.055 w=0.75 l=0.5
X6 VGND A2 a_822_107# VNB sky130_fd_pr__nfet_g5v0d10v5 ad=0.21375 pd=2.07 as=0.07875 ps=0.96 w=0.75 l=0.5
X7 VGND a_83_81# X VNB sky130_fd_pr__nfet_g5v0d10v5 ad=0.4425 pd=1.93 as=0.19875 ps=2.03 w=0.75 l=0.5
X8 a_316_443# A2 VPWR VPB sky130_fd_pr__pfet_g5v0d10v5 ad=0.3975 pd=3.53 as=0.21 ps=1.78 w=1.5 l=0.5
X9 VPWR a_83_81# X VPB sky130_fd_pr__pfet_g5v0d10v5 ad=0.4275 pd=3.57 as=0.4275 ps=3.57 w=1.5 l=0.5
.ends
