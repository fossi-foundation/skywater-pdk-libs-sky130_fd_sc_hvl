* Copyright 2026 FOSSi Foundation
*
* Licensed under the Apache License, Version 2.0 (the "License");
* you may not use this file except in compliance with the License.
* You may obtain a copy of the License at
*
*	https://www.apache.org/licenses/LICENSE-2.0
*
* Unless required by applicable law or agreed to in writing, software
* distributed under the License is distributed on an "AS IS" BASIS,
* WITHOUT WARRANTIES OR CONDITIONS OF ANY KIND, either express or implied.
* See the License for the specific language governing permissions and
* limitations under the License.
*
* SPDX-License-Identifier: Apache-2.0
* NGSPICE file created from sky130_fd_sc_hvl__dfstp_1.ext - technology: sky130A

.subckt sky130_fd_sc_hvl__dfstp_1 CLK D SET_B VGND VNB VPB VPWR Q
X0 VGND a_1787_137# a_2553_203# VNB sky130_fd_pr__nfet_g5v0d10v5 ad=0.12998 pd=1.145 as=0.1197 ps=1.41 w=0.42 l=0.5
X1 VPWR a_1000_81# a_982_529# VPB sky130_fd_pr__pfet_g5v0d10v5 ad=0.0987 pd=0.89 as=0.0441 ps=0.63 w=0.42 l=0.5
X2 Q a_2553_203# VPWR VPB sky130_fd_pr__pfet_g5v0d10v5 ad=0.265 pd=2.53 as=0.17375 ps=1.375 w=1 l=0.5
X3 a_642_107# D VPWR VPB sky130_fd_pr__pfet_g5v0d10v5 ad=0.0588 pd=0.7 as=0.2247 ps=1.91 w=0.42 l=0.5
X4 a_798_107# a_30_131# a_642_107# VNB sky130_fd_pr__nfet_g5v0d10v5 ad=0.063 pd=0.72 as=0.0588 ps=0.7 w=0.42 l=0.5
X5 a_2031_177# a_1787_137# VGND VNB sky130_fd_pr__nfet_g5v0d10v5 ad=0.1197 pd=1.41 as=0.0588 ps=0.7 w=0.42 l=0.5
X6 VPWR a_1787_137# a_2553_203# VPB sky130_fd_pr__pfet_g5v0d10v5 ad=0.17375 pd=1.375 as=0.19875 ps=2.03 w=0.75 l=0.5
X7 Q a_2553_203# VGND VNB sky130_fd_pr__nfet_g5v0d10v5 ad=0.21375 pd=2.07 as=0.12998 ps=1.145 w=0.75 l=0.5
X8 a_1000_81# a_798_107# VPWR VPB sky130_fd_pr__pfet_g5v0d10v5 ad=0.0588 pd=0.7 as=0.0987 ps=0.89 w=0.42 l=0.5
X9 a_1645_137# a_798_107# VGND VNB sky130_fd_pr__nfet_g5v0d10v5 ad=0.07875 pd=0.96 as=0.12247 ps=1.125 w=0.75 l=0.5
X10 a_1787_137# SET_B VPWR VPB sky130_fd_pr__pfet_g5v0d10v5 ad=0.11585 pd=1.41 as=0.0588 ps=0.7 w=0.42 l=0.5
X11 VGND CLK a_30_131# VNB sky130_fd_pr__nfet_g5v0d10v5 ad=0.0588 pd=0.7 as=0.1197 ps=1.41 w=0.42 l=0.5
X12 a_1787_137# a_340_593# a_1645_137# VNB sky130_fd_pr__nfet_g5v0d10v5 ad=0.14835 pd=1.26 as=0.07875 ps=0.96 w=0.75 l=0.5
X13 a_1989_203# a_30_131# a_1787_137# VNB sky130_fd_pr__nfet_g5v0d10v5 ad=0.0441 pd=0.63 as=0.14835 ps=1.26 w=0.42 l=0.5
X14 a_2131_203# a_2031_177# a_1989_203# VNB sky130_fd_pr__nfet_g5v0d10v5 ad=0.0441 pd=0.63 as=0.0441 ps=0.63 w=0.42 l=0.5
X15 VGND SET_B a_2131_203# VNB sky130_fd_pr__nfet_g5v0d10v5 ad=0.0588 pd=0.7 as=0.0441 ps=0.63 w=0.42 l=0.5
X16 a_1653_515# a_798_107# VPWR VPB sky130_fd_pr__pfet_g5v0d10v5 ad=0.105 pd=1.21 as=0.1656 ps=1.395 w=1 l=0.5
X17 VPWR a_1787_137# a_2031_177# VPB sky130_fd_pr__pfet_g5v0d10v5 ad=0.1113 pd=1.37 as=0.1848 ps=1.72 w=0.42 l=0.5
X18 VPWR CLK a_30_131# VPB sky130_fd_pr__pfet_g5v0d10v5 ad=0.105 pd=1.03 as=0.19875 ps=2.03 w=0.75 l=0.5
X19 a_1787_137# a_30_131# a_1653_515# VPB sky130_fd_pr__pfet_g5v0d10v5 ad=0.2031 pd=1.47 as=0.105 ps=1.21 w=1 l=0.5
X20 a_958_107# a_340_593# a_798_107# VNB sky130_fd_pr__nfet_g5v0d10v5 ad=0.0441 pd=0.63 as=0.063 ps=0.72 w=0.42 l=0.5
X21 VGND SET_B a_1268_251# VNB sky130_fd_pr__nfet_g5v0d10v5 ad=0.12247 pd=1.125 as=0.1419 ps=1.17 w=0.42 l=0.5
X22 a_982_529# a_30_131# a_798_107# VPB sky130_fd_pr__pfet_g5v0d10v5 ad=0.0441 pd=0.63 as=0.0672 ps=0.74 w=0.42 l=0.5
X23 a_1268_251# a_798_107# a_1000_81# VNB sky130_fd_pr__nfet_g5v0d10v5 ad=0.1419 pd=1.17 as=0.1113 ps=1.37 w=0.42 l=0.5
X24 a_642_107# D VGND VNB sky130_fd_pr__nfet_g5v0d10v5 ad=0.0588 pd=0.7 as=0.1197 ps=1.41 w=0.42 l=0.5
X25 a_798_107# a_340_593# a_642_107# VPB sky130_fd_pr__pfet_g5v0d10v5 ad=0.0672 pd=0.74 as=0.0588 ps=0.7 w=0.42 l=0.5
X26 VPWR SET_B a_1000_81# VPB sky130_fd_pr__pfet_g5v0d10v5 ad=0.1656 pd=1.395 as=0.0588 ps=0.7 w=0.42 l=0.5
X27 a_340_593# a_30_131# VGND VNB sky130_fd_pr__nfet_g5v0d10v5 ad=0.1197 pd=1.41 as=0.0588 ps=0.7 w=0.42 l=0.5
X28 a_340_593# a_30_131# VPWR VPB sky130_fd_pr__pfet_g5v0d10v5 ad=0.19875 pd=2.03 as=0.105 ps=1.03 w=0.75 l=0.5
X29 a_1989_515# a_340_593# a_1787_137# VPB sky130_fd_pr__pfet_g5v0d10v5 ad=0.0441 pd=0.63 as=0.2031 ps=1.47 w=0.42 l=0.5
X30 VPWR a_2031_177# a_1989_515# VPB sky130_fd_pr__pfet_g5v0d10v5 ad=0.0588 pd=0.7 as=0.0441 ps=0.63 w=0.42 l=0.5
X31 VGND a_1000_81# a_958_107# VNB sky130_fd_pr__nfet_g5v0d10v5 ad=0.1113 pd=1.37 as=0.0441 ps=0.63 w=0.42 l=0.5
.ends
