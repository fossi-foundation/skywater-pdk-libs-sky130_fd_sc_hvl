* Copyright 2026 FOSSi Foundation
*
* Licensed under the Apache License, Version 2.0 (the "License");
* you may not use this file except in compliance with the License.
* You may obtain a copy of the License at
*
*	https://www.apache.org/licenses/LICENSE-2.0
*
* Unless required by applicable law or agreed to in writing, software
* distributed under the License is distributed on an "AS IS" BASIS,
* WITHOUT WARRANTIES OR CONDITIONS OF ANY KIND, either express or implied.
* See the License for the specific language governing permissions and
* limitations under the License.
*
* SPDX-License-Identifier: Apache-2.0
* NGSPICE file created from sky130_fd_sc_hvl__dlclkp_1.ext - technology: sky130A

.subckt sky130_fd_sc_hvl__dlclkp_1 CLK GATE VGND VNB VPB VPWR GCLK
X0 a_189_445# GATE VPWR VPB sky130_fd_pr__pfet_g5v0d10v5 ad=0.09375 pd=1 as=0.22125 ps=2.09 w=0.75 l=0.5
X1 a_1027_159# a_239_419# a_303_311# VNB sky130_fd_pr__nfet_g5v0d10v5 ad=0.0441 pd=0.63 as=0.1113 ps=1.37 w=0.42 l=0.5
X2 a_231_71# CLK VGND VNB sky130_fd_pr__nfet_g5v0d10v5 ad=0.1113 pd=1.37 as=0.0588 ps=0.7 w=0.42 l=0.5
X3 a_1438_171# a_1069_133# VPWR VPB sky130_fd_pr__pfet_g5v0d10v5 ad=0.105 pd=1.03 as=0.19875 ps=2.03 w=0.75 l=0.5
X4 VGND a_1069_133# a_1027_159# VNB sky130_fd_pr__nfet_g5v0d10v5 ad=0.0588 pd=0.7 as=0.0441 ps=0.63 w=0.42 l=0.5
X5 VGND CLK a_1591_171# VNB sky130_fd_pr__nfet_g5v0d10v5 ad=0.11513 pd=1.09 as=0.0588 ps=0.7 w=0.42 l=0.5
X6 GCLK a_1438_171# VGND VNB sky130_fd_pr__nfet_g5v0d10v5 ad=0.19875 pd=2.03 as=0.11513 ps=1.09 w=0.75 l=0.5
X7 a_303_311# a_231_71# a_189_159# VNB sky130_fd_pr__nfet_g5v0d10v5 ad=0.1113 pd=1.37 as=0.0525 ps=0.67 w=0.42 l=0.5
X8 a_231_71# CLK VPWR VPB sky130_fd_pr__pfet_g5v0d10v5 ad=0.19875 pd=2.03 as=0.105 ps=1.03 w=0.75 l=0.5
X9 a_303_311# a_239_419# a_189_445# VPB sky130_fd_pr__pfet_g5v0d10v5 ad=0.19875 pd=2.03 as=0.09375 ps=1 w=0.75 l=0.5
X10 a_1069_133# a_303_311# VPWR VPB sky130_fd_pr__pfet_g5v0d10v5 ad=0.1113 pd=1.37 as=0.0588 ps=0.7 w=0.42 l=0.5
X11 a_1591_171# a_1069_133# a_1438_171# VNB sky130_fd_pr__nfet_g5v0d10v5 ad=0.0588 pd=0.7 as=0.1113 ps=1.37 w=0.42 l=0.5
X12 a_1027_457# a_231_71# a_303_311# VPB sky130_fd_pr__pfet_g5v0d10v5 ad=0.0441 pd=0.63 as=0.1113 ps=1.37 w=0.42 l=0.5
X13 VPWR a_1069_133# a_1027_457# VPB sky130_fd_pr__pfet_g5v0d10v5 ad=0.0588 pd=0.7 as=0.0441 ps=0.63 w=0.42 l=0.5
X14 VGND a_231_71# a_239_419# VNB sky130_fd_pr__nfet_g5v0d10v5 ad=0.0588 pd=0.7 as=0.1113 ps=1.37 w=0.42 l=0.5
X15 GCLK a_1438_171# VPWR VPB sky130_fd_pr__pfet_g5v0d10v5 ad=0.3975 pd=3.53 as=0.22688 ps=1.84 w=1.5 l=0.5
X16 VPWR a_231_71# a_239_419# VPB sky130_fd_pr__pfet_g5v0d10v5 ad=0.105 pd=1.03 as=0.19875 ps=2.03 w=0.75 l=0.5
X17 VPWR CLK a_1438_171# VPB sky130_fd_pr__pfet_g5v0d10v5 ad=0.22688 pd=1.84 as=0.105 ps=1.03 w=0.75 l=0.5
X18 a_1069_133# a_303_311# VGND VNB sky130_fd_pr__nfet_g5v0d10v5 ad=0.1113 pd=1.37 as=0.0588 ps=0.7 w=0.42 l=0.5
X19 a_189_159# GATE VGND VNB sky130_fd_pr__nfet_g5v0d10v5 ad=0.0525 pd=0.67 as=0.1239 ps=1.43 w=0.42 l=0.5
.ends
