* Copyright 2026 FOSSi Foundation
*
* Licensed under the Apache License, Version 2.0 (the "License");
* you may not use this file except in compliance with the License.
* You may obtain a copy of the License at
*
*	https://www.apache.org/licenses/LICENSE-2.0
*
* Unless required by applicable law or agreed to in writing, software
* distributed under the License is distributed on an "AS IS" BASIS,
* WITHOUT WARRANTIES OR CONDITIONS OF ANY KIND, either express or implied.
* See the License for the specific language governing permissions and
* limitations under the License.
*
* SPDX-License-Identifier: Apache-2.0
* NGSPICE file created from sky130_fd_sc_hvl__sdfxbp_1.ext - technology: sky130A

.subckt sky130_fd_sc_hvl__sdfxbp_1 CLK D SCD SCE VGND VNB VPB VPWR Q Q_N
X0 VPWR SCD a_268_659# VPB sky130_fd_pr__pfet_g5v0d10v5 ad=0.0588 pd=0.7 as=0.1197 ps=1.41 w=0.42 l=0.5
X1 a_1528_579# a_1067_107# VPWR VPB sky130_fd_pr__pfet_g5v0d10v5 ad=0.0441 pd=0.63 as=0.2496 ps=1.795 w=0.42 l=0.5
X2 a_1124_81# a_1570_457# a_1528_579# VPB sky130_fd_pr__pfet_g5v0d10v5 ad=0.0588 pd=0.7 as=0.0441 ps=0.63 w=0.42 l=0.5
X3 a_1454_173# a_1067_107# VGND VNB sky130_fd_pr__nfet_g5v0d10v5 ad=0.1197 pd=1.41 as=0.19672 ps=1.4 w=0.42 l=0.5
X4 a_581_659# D a_567_107# VPB sky130_fd_pr__pfet_g5v0d10v5 ad=0.1113 pd=1.37 as=0.0588 ps=0.7 w=0.42 l=0.5
X5 a_1570_457# CLK VPWR VPB sky130_fd_pr__pfet_g5v0d10v5 ad=0.19875 pd=2.03 as=0.105 ps=1.03 w=0.75 l=0.5
X6 a_723_107# a_30_515# a_567_107# VNB sky130_fd_pr__nfet_g5v0d10v5 ad=0.0441 pd=0.63 as=0.0588 ps=0.7 w=0.42 l=0.5
X7 VPWR a_2789_147# Q VPB sky130_fd_pr__pfet_g5v0d10v5 ad=0.24 pd=1.875 as=0.3975 ps=3.53 w=1.5 l=0.5
X8 VGND D a_723_107# VNB sky130_fd_pr__nfet_g5v0d10v5 ad=0.1197 pd=1.41 as=0.0441 ps=0.63 w=0.42 l=0.5
X9 a_1124_81# a_1570_457# a_567_107# VNB sky130_fd_pr__nfet_g5v0d10v5 ad=0.0588 pd=0.7 as=0.1197 ps=1.41 w=0.42 l=0.5
X10 a_2789_147# a_2518_445# VPWR VPB sky130_fd_pr__pfet_g5v0d10v5 ad=0.265 pd=2.53 as=0.1556 ps=1.375 w=1 l=0.5
X11 a_425_107# SCD VGND VNB sky130_fd_pr__nfet_g5v0d10v5 ad=0.0441 pd=0.63 as=0.0588 ps=0.7 w=0.42 l=0.5
X12 a_567_107# a_30_515# a_268_659# VPB sky130_fd_pr__pfet_g5v0d10v5 ad=0.0588 pd=0.7 as=0.1113 ps=1.37 w=0.42 l=0.5
X13 a_567_107# SCE a_425_107# VNB sky130_fd_pr__nfet_g5v0d10v5 ad=0.0588 pd=0.7 as=0.0441 ps=0.63 w=0.42 l=0.5
X14 a_581_659# SCE VPWR VPB sky130_fd_pr__pfet_g5v0d10v5 ad=0.1113 pd=1.37 as=0.0588 ps=0.7 w=0.42 l=0.5
X15 Q_N a_3531_107# VPWR VPB sky130_fd_pr__pfet_g5v0d10v5 ad=0.4275 pd=3.57 as=0.4275 ps=3.57 w=1.5 l=0.5
X16 VPWR SCE a_30_515# VPB sky130_fd_pr__pfet_g5v0d10v5 ad=0.1197 pd=1.41 as=0.1113 ps=1.37 w=0.42 l=0.5
X17 VPWR a_2789_147# a_2365_445# VPB sky130_fd_pr__pfet_g5v0d10v5 ad=0.1556 pd=1.375 as=0.1113 ps=1.37 w=0.42 l=0.5
X18 a_1570_457# CLK VGND VNB sky130_fd_pr__nfet_g5v0d10v5 ad=0.1197 pd=1.41 as=0.0588 ps=0.7 w=0.42 l=0.5
X19 VPWR a_1570_457# a_1726_453# VPB sky130_fd_pr__pfet_g5v0d10v5 ad=0.105 pd=1.03 as=0.19875 ps=2.03 w=0.75 l=0.5
X20 a_1067_107# a_1570_457# a_2518_445# VPB sky130_fd_pr__pfet_g5v0d10v5 ad=0.285 pd=2.57 as=0.1556 ps=1.375 w=1 l=0.5
X21 VGND SCE a_30_515# VNB sky130_fd_pr__nfet_g5v0d10v5 ad=0.0588 pd=0.7 as=0.1197 ps=1.41 w=0.42 l=0.5
X22 a_2747_173# a_1570_457# a_2518_445# VNB sky130_fd_pr__nfet_g5v0d10v5 ad=0.0441 pd=0.63 as=0.0588 ps=0.7 w=0.42 l=0.5
X23 VGND a_2789_147# a_2747_173# VNB sky130_fd_pr__nfet_g5v0d10v5 ad=0.12998 pd=1.145 as=0.0441 ps=0.63 w=0.42 l=0.5
X24 a_3531_107# a_2789_147# VGND VNB sky130_fd_pr__nfet_g5v0d10v5 ad=0.1197 pd=1.41 as=0.12998 ps=1.145 w=0.42 l=0.5
X25 a_1454_173# a_1726_453# a_1124_81# VNB sky130_fd_pr__nfet_g5v0d10v5 ad=0.1197 pd=1.41 as=0.0588 ps=0.7 w=0.42 l=0.5
X26 a_567_107# a_1726_453# a_1124_81# VPB sky130_fd_pr__pfet_g5v0d10v5 ad=0.1197 pd=1.41 as=0.0588 ps=0.7 w=0.42 l=0.5
X27 VGND a_1124_81# a_1067_107# VNB sky130_fd_pr__nfet_g5v0d10v5 ad=0.19672 pd=1.4 as=0.21375 ps=2.07 w=0.75 l=0.5
X28 a_3531_107# a_2789_147# VPWR VPB sky130_fd_pr__pfet_g5v0d10v5 ad=0.19875 pd=2.03 as=0.24 ps=1.875 w=0.75 l=0.5
X29 VGND a_1570_457# a_1726_453# VNB sky130_fd_pr__nfet_g5v0d10v5 ad=0.0588 pd=0.7 as=0.1197 ps=1.41 w=0.42 l=0.5
X30 a_2518_445# a_1726_453# a_2365_445# VPB sky130_fd_pr__pfet_g5v0d10v5 ad=0.1556 pd=1.375 as=0.1113 ps=1.37 w=0.42 l=0.5
X31 a_2518_445# a_1726_453# a_1067_107# VNB sky130_fd_pr__nfet_g5v0d10v5 ad=0.0588 pd=0.7 as=0.1197 ps=1.41 w=0.42 l=0.5
X32 VPWR a_1124_81# a_1067_107# VPB sky130_fd_pr__pfet_g5v0d10v5 ad=0.2496 pd=1.795 as=0.265 ps=2.53 w=1 l=0.5
X33 a_2789_147# a_2518_445# VGND VNB sky130_fd_pr__nfet_g5v0d10v5 ad=0.21375 pd=2.07 as=0.12998 ps=1.145 w=0.75 l=0.5
X34 VGND a_2789_147# Q VNB sky130_fd_pr__nfet_g5v0d10v5 ad=0.12998 pd=1.145 as=0.21375 ps=2.07 w=0.75 l=0.5
X35 Q_N a_3531_107# VGND VNB sky130_fd_pr__nfet_g5v0d10v5 ad=0.21375 pd=2.07 as=0.21375 ps=2.07 w=0.75 l=0.5
.ends
