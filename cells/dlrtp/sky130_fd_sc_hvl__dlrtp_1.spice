* Copyright 2026 FOSSi Foundation
*
* Licensed under the Apache License, Version 2.0 (the "License");
* you may not use this file except in compliance with the License.
* You may obtain a copy of the License at
*
*	https://www.apache.org/licenses/LICENSE-2.0
*
* Unless required by applicable law or agreed to in writing, software
* distributed under the License is distributed on an "AS IS" BASIS,
* WITHOUT WARRANTIES OR CONDITIONS OF ANY KIND, either express or implied.
* See the License for the specific language governing permissions and
* limitations under the License.
*
* SPDX-License-Identifier: Apache-2.0
* NGSPICE file created from sky130_fd_sc_hvl__dlrtp_1.ext - technology: sky130A

.subckt sky130_fd_sc_hvl__dlrtp_1 D GATE RESET_B VGND VNB VPB VPWR Q
X0 VPWR a_345_107# a_462_107# VPB sky130_fd_pr__pfet_g5v0d10v5 ad=0.105 pd=1.03 as=0.21375 ps=2.07 w=0.75 l=0.5
X1 VPWR RESET_B a_1138_81# VPB sky130_fd_pr__pfet_g5v0d10v5 ad=0.255 pd=1.895 as=0.105 ps=1.03 w=0.75 l=0.5
X2 a_345_107# GATE VPWR VPB sky130_fd_pr__pfet_g5v0d10v5 ad=0.21375 pd=2.07 as=0.105 ps=1.03 w=0.75 l=0.5
X3 a_345_107# GATE VGND VNB sky130_fd_pr__nfet_g5v0d10v5 ad=0.1197 pd=1.41 as=0.0588 ps=0.7 w=0.42 l=0.5
X4 a_775_107# a_32_107# VGND VNB sky130_fd_pr__nfet_g5v0d10v5 ad=0.0441 pd=0.63 as=0.0588 ps=0.7 w=0.42 l=0.5
X5 a_1096_491# a_462_107# a_917_107# VPB sky130_fd_pr__pfet_g5v0d10v5 ad=0.0441 pd=0.63 as=0.12998 ps=1.145 w=0.42 l=0.5
X6 VGND a_1138_81# a_1096_107# VNB sky130_fd_pr__nfet_g5v0d10v5 ad=0.1197 pd=1.41 as=0.0441 ps=0.63 w=0.42 l=0.5
X7 a_917_107# a_462_107# a_775_107# VNB sky130_fd_pr__nfet_g5v0d10v5 ad=0.08295 pd=0.815 as=0.0441 ps=0.63 w=0.42 l=0.5
X8 a_775_491# a_32_107# VPWR VPB sky130_fd_pr__pfet_g5v0d10v5 ad=0.07875 pd=0.96 as=0.105 ps=1.03 w=0.75 l=0.5
X9 a_1138_81# a_917_107# VPWR VPB sky130_fd_pr__pfet_g5v0d10v5 ad=0.105 pd=1.03 as=0.12998 ps=1.145 w=0.75 l=0.5
X10 VPWR a_1138_81# a_1096_491# VPB sky130_fd_pr__pfet_g5v0d10v5 ad=0.12998 pd=1.145 as=0.0441 ps=0.63 w=0.42 l=0.5
X11 Q a_1138_81# VGND VNB sky130_fd_pr__nfet_g5v0d10v5 ad=0.21375 pd=2.07 as=0.12998 ps=1.145 w=0.75 l=0.5
X12 VPWR D a_32_107# VPB sky130_fd_pr__pfet_g5v0d10v5 ad=0.105 pd=1.03 as=0.21375 ps=2.07 w=0.75 l=0.5
X13 VGND a_345_107# a_462_107# VNB sky130_fd_pr__nfet_g5v0d10v5 ad=0.0588 pd=0.7 as=0.1197 ps=1.41 w=0.42 l=0.5
X14 a_917_107# a_345_107# a_775_491# VPB sky130_fd_pr__pfet_g5v0d10v5 ad=0.12998 pd=1.145 as=0.07875 ps=0.96 w=0.75 l=0.5
X15 Q a_1138_81# VPWR VPB sky130_fd_pr__pfet_g5v0d10v5 ad=0.4275 pd=3.57 as=0.255 ps=1.895 w=1.5 l=0.5
X16 VGND D a_32_107# VNB sky130_fd_pr__nfet_g5v0d10v5 ad=0.0588 pd=0.7 as=0.1197 ps=1.41 w=0.42 l=0.5
X17 a_1512_107# a_917_107# a_1138_81# VNB sky130_fd_pr__nfet_g5v0d10v5 ad=0.0441 pd=0.63 as=0.1197 ps=1.41 w=0.42 l=0.5
X18 VGND RESET_B a_1512_107# VNB sky130_fd_pr__nfet_g5v0d10v5 ad=0.12998 pd=1.145 as=0.0441 ps=0.63 w=0.42 l=0.5
X19 a_1096_107# a_345_107# a_917_107# VNB sky130_fd_pr__nfet_g5v0d10v5 ad=0.0441 pd=0.63 as=0.08295 ps=0.815 w=0.42 l=0.5
.ends
