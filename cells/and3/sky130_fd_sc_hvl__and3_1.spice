* Copyright 2026 FOSSi Foundation
*
* Licensed under the Apache License, Version 2.0 (the "License");
* you may not use this file except in compliance with the License.
* You may obtain a copy of the License at
*
*	https://www.apache.org/licenses/LICENSE-2.0
*
* Unless required by applicable law or agreed to in writing, software
* distributed under the License is distributed on an "AS IS" BASIS,
* WITHOUT WARRANTIES OR CONDITIONS OF ANY KIND, either express or implied.
* See the License for the specific language governing permissions and
* limitations under the License.
*
* SPDX-License-Identifier: Apache-2.0
* NGSPICE file created from sky130_fd_sc_hvl__and3_1.ext - technology: sky130A

.subckt sky130_fd_sc_hvl__and3_1 A B C VGND VNB VPB VPWR X
X0 X a_30_517# VGND VNB sky130_fd_pr__nfet_g5v0d10v5 ad=0.19875 pd=2.03 as=0.15202 ps=1.25 w=0.75 l=0.5
X1 a_201_173# A a_30_517# VNB sky130_fd_pr__nfet_g5v0d10v5 ad=0.0441 pd=0.63 as=0.1302 ps=1.46 w=0.42 l=0.5
X2 a_30_517# B VPWR VPB sky130_fd_pr__pfet_g5v0d10v5 ad=0.0588 pd=0.7 as=0.0588 ps=0.7 w=0.42 l=0.5
X3 a_343_173# B a_201_173# VNB sky130_fd_pr__nfet_g5v0d10v5 ad=0.0441 pd=0.63 as=0.0441 ps=0.63 w=0.42 l=0.5
X4 VGND C a_343_173# VNB sky130_fd_pr__nfet_g5v0d10v5 ad=0.15202 pd=1.25 as=0.0441 ps=0.63 w=0.42 l=0.5
X5 X a_30_517# VPWR VPB sky130_fd_pr__pfet_g5v0d10v5 ad=0.4275 pd=3.57 as=0.23685 ps=1.895 w=1.5 l=0.5
X6 VPWR C a_30_517# VPB sky130_fd_pr__pfet_g5v0d10v5 ad=0.23685 pd=1.895 as=0.0588 ps=0.7 w=0.42 l=0.5
X7 VPWR A a_30_517# VPB sky130_fd_pr__pfet_g5v0d10v5 ad=0.0588 pd=0.7 as=0.1197 ps=1.41 w=0.42 l=0.5
.ends
