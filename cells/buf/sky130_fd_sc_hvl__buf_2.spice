* Copyright 2026 FOSSi Foundation
*
* Licensed under the Apache License, Version 2.0 (the "License");
* you may not use this file except in compliance with the License.
* You may obtain a copy of the License at
*
*	https://www.apache.org/licenses/LICENSE-2.0
*
* Unless required by applicable law or agreed to in writing, software
* distributed under the License is distributed on an "AS IS" BASIS,
* WITHOUT WARRANTIES OR CONDITIONS OF ANY KIND, either express or implied.
* See the License for the specific language governing permissions and
* limitations under the License.
*
* SPDX-License-Identifier: Apache-2.0
* NGSPICE file created from sky130_fd_sc_hvl__buf_2.ext - technology: sky130A

.subckt sky130_fd_sc_hvl__buf_2 A VGND VNB VPB VPWR X
X0 a_129_279# A VPWR VPB sky130_fd_pr__pfet_g5v0d10v5 ad=0.21375 pd=2.07 as=0.29438 ps=2 w=0.75 l=0.5
X1 X a_129_279# VPWR VPB sky130_fd_pr__pfet_g5v0d10v5 ad=0.21 pd=1.78 as=0.4275 ps=3.57 w=1.5 l=0.5
X2 X a_129_279# VGND VNB sky130_fd_pr__nfet_g5v0d10v5 ad=0.105 pd=1.03 as=0.21375 ps=2.07 w=0.75 l=0.5
X3 VPWR a_129_279# X VPB sky130_fd_pr__pfet_g5v0d10v5 ad=0.29438 pd=2 as=0.21 ps=1.78 w=1.5 l=0.5
X4 a_129_279# A VGND VNB sky130_fd_pr__nfet_g5v0d10v5 ad=0.1113 pd=1.37 as=0.15202 ps=1.25 w=0.42 l=0.5
X5 VGND a_129_279# X VNB sky130_fd_pr__nfet_g5v0d10v5 ad=0.15202 pd=1.25 as=0.105 ps=1.03 w=0.75 l=0.5
.ends
