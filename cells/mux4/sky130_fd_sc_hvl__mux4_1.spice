* Copyright 2026 FOSSi Foundation
*
* Licensed under the Apache License, Version 2.0 (the "License");
* you may not use this file except in compliance with the License.
* You may obtain a copy of the License at
*
*	https://www.apache.org/licenses/LICENSE-2.0
*
* Unless required by applicable law or agreed to in writing, software
* distributed under the License is distributed on an "AS IS" BASIS,
* WITHOUT WARRANTIES OR CONDITIONS OF ANY KIND, either express or implied.
* See the License for the specific language governing permissions and
* limitations under the License.
*
* SPDX-License-Identifier: Apache-2.0
* NGSPICE file created from sky130_fd_sc_hvl__mux4_1.ext - technology: sky130A

.subckt sky130_fd_sc_hvl__mux4_1 A0 A1 A2 A3 S0 S1 VGND VNB VPB VPWR X
X0 a_339_627# A2 VPWR VPB sky130_fd_pr__pfet_g5v0d10v5 ad=0.0441 pd=0.63 as=0.0588 ps=0.7 w=0.42 l=0.5
X1 a_1097_627# a_30_107# a_955_627# VPB sky130_fd_pr__pfet_g5v0d10v5 ad=0.0588 pd=0.7 as=0.0441 ps=0.63 w=0.42 l=0.5
X2 a_1669_615# S1 a_1097_627# VPB sky130_fd_pr__pfet_g5v0d10v5 ad=0.0588 pd=0.7 as=0.1197 ps=1.41 w=0.42 l=0.5
X3 a_481_107# S1 a_1669_615# VNB sky130_fd_pr__nfet_g5v0d10v5 ad=0.1197 pd=1.41 as=0.0588 ps=0.7 w=0.42 l=0.5
X4 VGND A0 a_1281_107# VNB sky130_fd_pr__nfet_g5v0d10v5 ad=0.1197 pd=1.41 as=0.0441 ps=0.63 w=0.42 l=0.5
X5 a_339_107# A2 VGND VNB sky130_fd_pr__nfet_g5v0d10v5 ad=0.0441 pd=0.63 as=0.0588 ps=0.7 w=0.42 l=0.5
X6 a_481_107# a_30_107# a_339_107# VNB sky130_fd_pr__nfet_g5v0d10v5 ad=0.0588 pd=0.7 as=0.0441 ps=0.63 w=0.42 l=0.5
X7 VPWR A3 a_637_627# VPB sky130_fd_pr__pfet_g5v0d10v5 ad=0.0588 pd=0.7 as=0.0651 ps=0.73 w=0.42 l=0.5
X8 VGND S1 a_1681_89# VNB sky130_fd_pr__nfet_g5v0d10v5 ad=0.14992 pd=1.24 as=0.1197 ps=1.41 w=0.42 l=0.5
X9 a_1669_615# a_1681_89# a_1097_627# VNB sky130_fd_pr__nfet_g5v0d10v5 ad=0.0588 pd=0.7 as=0.1197 ps=1.41 w=0.42 l=0.5
X10 a_1097_627# S0 a_983_107# VNB sky130_fd_pr__nfet_g5v0d10v5 ad=0.0588 pd=0.7 as=0.0441 ps=0.63 w=0.42 l=0.5
X11 VPWR S0 a_30_107# VPB sky130_fd_pr__pfet_g5v0d10v5 ad=0.0588 pd=0.7 as=0.1113 ps=1.37 w=0.42 l=0.5
X12 VPWR S1 a_1681_89# VPB sky130_fd_pr__pfet_g5v0d10v5 ad=0.3081 pd=1.99 as=0.1113 ps=1.37 w=0.42 l=0.5
X13 X a_1669_615# VPWR VPB sky130_fd_pr__pfet_g5v0d10v5 ad=0.3975 pd=3.53 as=0.3081 ps=1.99 w=1.5 l=0.5
X14 a_637_627# a_30_107# a_481_107# VPB sky130_fd_pr__pfet_g5v0d10v5 ad=0.0651 pd=0.73 as=0.0588 ps=0.7 w=0.42 l=0.5
X15 VGND S0 a_30_107# VNB sky130_fd_pr__nfet_g5v0d10v5 ad=0.0588 pd=0.7 as=0.1113 ps=1.37 w=0.42 l=0.5
X16 a_481_107# a_1681_89# a_1669_615# VPB sky130_fd_pr__pfet_g5v0d10v5 ad=0.2751 pd=2.15 as=0.0588 ps=0.7 w=0.42 l=0.5
X17 a_1253_627# S0 a_1097_627# VPB sky130_fd_pr__pfet_g5v0d10v5 ad=0.0441 pd=0.63 as=0.0588 ps=0.7 w=0.42 l=0.5
X18 a_1281_107# a_30_107# a_1097_627# VNB sky130_fd_pr__nfet_g5v0d10v5 ad=0.0441 pd=0.63 as=0.0588 ps=0.7 w=0.42 l=0.5
X19 X a_1669_615# VGND VNB sky130_fd_pr__nfet_g5v0d10v5 ad=0.19875 pd=2.03 as=0.14992 ps=1.24 w=0.75 l=0.5
X20 VPWR A0 a_1253_627# VPB sky130_fd_pr__pfet_g5v0d10v5 ad=0.1197 pd=1.41 as=0.0441 ps=0.63 w=0.42 l=0.5
X21 a_637_107# S0 a_481_107# VNB sky130_fd_pr__nfet_g5v0d10v5 ad=0.0441 pd=0.63 as=0.0588 ps=0.7 w=0.42 l=0.5
X22 VGND A3 a_637_107# VNB sky130_fd_pr__nfet_g5v0d10v5 ad=0.1092 pd=0.94 as=0.0441 ps=0.63 w=0.42 l=0.5
X23 a_481_107# S0 a_339_627# VPB sky130_fd_pr__pfet_g5v0d10v5 ad=0.0588 pd=0.7 as=0.0441 ps=0.63 w=0.42 l=0.5
X24 a_955_627# A1 VPWR VPB sky130_fd_pr__pfet_g5v0d10v5 ad=0.0441 pd=0.63 as=0.0588 ps=0.7 w=0.42 l=0.5
X25 a_983_107# A1 VGND VNB sky130_fd_pr__nfet_g5v0d10v5 ad=0.0441 pd=0.63 as=0.1092 ps=0.94 w=0.42 l=0.5
.ends
