* Copyright 2026 FOSSi Foundation
*
* Licensed under the Apache License, Version 2.0 (the "License");
* you may not use this file except in compliance with the License.
* You may obtain a copy of the License at
*
*	https://www.apache.org/licenses/LICENSE-2.0
*
* Unless required by applicable law or agreed to in writing, software
* distributed under the License is distributed on an "AS IS" BASIS,
* WITHOUT WARRANTIES OR CONDITIONS OF ANY KIND, either express or implied.
* See the License for the specific language governing permissions and
* limitations under the License.
*
* SPDX-License-Identifier: Apache-2.0
* NGSPICE file created from sky130_fd_sc_hvl__sdfrbp_1.ext - technology: sky130A

.subckt sky130_fd_sc_hvl__sdfrbp_1 CLK D RESET_B SCD SCE VGND VNB VPB VPWR Q Q_N
X0 VGND a_2624_107# a_3613_443# VNB sky130_fd_pr__nfet_g5v0d10v5 ad=0.12247 pd=1.125 as=0.1113 ps=1.37 w=0.42 l=0.5
X1 a_496_655# D a_339_655# VPB sky130_fd_pr__pfet_g5v0d10v5 ad=0.0441 pd=0.63 as=0.1197 ps=1.41 w=0.42 l=0.5
X2 a_1290_126# CLK VPWR VPB sky130_fd_pr__pfet_g5v0d10v5 ad=0.21375 pd=2.07 as=0.14153 ps=1.2 w=0.75 l=0.5
X3 a_2014_537# a_1816_659# VPWR VPB sky130_fd_pr__pfet_g5v0d10v5 ad=0.14 pd=1.28 as=0.265 ps=2.53 w=1 l=0.5
X4 a_339_655# a_222_131# a_794_655# VPB sky130_fd_pr__pfet_g5v0d10v5 ad=0.0672 pd=0.74 as=0.0441 ps=0.63 w=0.42 l=0.5
X5 Q a_3613_443# VGND VNB sky130_fd_pr__nfet_g5v0d10v5 ad=0.19875 pd=2.03 as=0.12247 ps=1.125 w=0.75 l=0.5
X6 a_3098_107# RESET_B VGND VNB sky130_fd_pr__nfet_g5v0d10v5 ad=0.0441 pd=0.63 as=0.05985 ps=0.705 w=0.42 l=0.5
X7 a_2841_81# a_2624_107# a_3098_107# VNB sky130_fd_pr__nfet_g5v0d10v5 ad=0.1113 pd=1.37 as=0.0441 ps=0.63 w=0.42 l=0.5
X8 a_2871_543# a_1569_126# a_2624_107# VPB sky130_fd_pr__pfet_g5v0d10v5 ad=0.0441 pd=0.63 as=0.1656 ps=1.395 w=0.42 l=0.5
X9 a_2799_107# a_1290_126# a_2624_107# VNB sky130_fd_pr__nfet_g5v0d10v5 ad=0.0441 pd=0.63 as=0.12247 ps=1.125 w=0.42 l=0.5
X10 VPWR RESET_B a_339_655# VPB sky130_fd_pr__pfet_g5v0d10v5 ad=0.14153 pd=1.2 as=0.0672 ps=0.74 w=0.42 l=0.5
X11 a_1816_659# RESET_B VPWR VPB sky130_fd_pr__pfet_g5v0d10v5 ad=0.1113 pd=1.37 as=0.0588 ps=0.7 w=0.42 l=0.5
X12 VPWR SCE a_496_655# VPB sky130_fd_pr__pfet_g5v0d10v5 ad=0.0588 pd=0.7 as=0.0441 ps=0.63 w=0.42 l=0.5
X13 a_1816_659# a_1569_126# a_339_655# VPB sky130_fd_pr__pfet_g5v0d10v5 ad=0.0588 pd=0.7 as=0.1197 ps=1.41 w=0.42 l=0.5
X14 a_222_131# SCE VPWR VPB sky130_fd_pr__pfet_g5v0d10v5 ad=0.1197 pd=1.41 as=0.1197 ps=1.41 w=0.42 l=0.5
X15 a_1569_126# a_1290_126# VPWR VPB sky130_fd_pr__pfet_g5v0d10v5 ad=0.19875 pd=2.03 as=0.21375 ps=2.07 w=0.75 l=0.5
X16 Q_N a_2624_107# VGND VNB sky130_fd_pr__nfet_g5v0d10v5 ad=0.19875 pd=2.03 as=0.19875 ps=2.03 w=0.75 l=0.5
X17 a_1290_126# CLK VGND VNB sky130_fd_pr__nfet_g5v0d10v5 ad=0.1197 pd=1.41 as=0.0588 ps=0.7 w=0.42 l=0.5
X18 a_1816_659# a_1290_126# a_339_655# VNB sky130_fd_pr__nfet_g5v0d10v5 ad=0.0588 pd=0.7 as=0.1197 ps=1.41 w=0.42 l=0.5
X19 a_2624_107# a_1569_126# a_2014_537# VNB sky130_fd_pr__nfet_g5v0d10v5 ad=0.12247 pd=1.125 as=0.105 ps=1.03 w=0.75 l=0.5
X20 a_222_131# SCE VGND VNB sky130_fd_pr__nfet_g5v0d10v5 ad=0.1197 pd=1.41 as=0.1197 ps=1.41 w=0.42 l=0.5
X21 VPWR a_2624_107# a_2841_81# VPB sky130_fd_pr__pfet_g5v0d10v5 ad=0.22185 pd=1.875 as=0.0588 ps=0.7 w=0.42 l=0.5
X22 Q a_3613_443# VPWR VPB sky130_fd_pr__pfet_g5v0d10v5 ad=0.4275 pd=3.57 as=0.255 ps=1.895 w=1.5 l=0.5
X23 a_2624_107# a_1290_126# a_2014_537# VPB sky130_fd_pr__pfet_g5v0d10v5 ad=0.1656 pd=1.395 as=0.14 ps=1.28 w=1 l=0.5
X24 VGND a_2841_81# a_2799_107# VNB sky130_fd_pr__nfet_g5v0d10v5 ad=0.05985 pd=0.705 as=0.0441 ps=0.63 w=0.42 l=0.5
X25 VPWR a_2841_81# a_2871_543# VPB sky130_fd_pr__pfet_g5v0d10v5 ad=0.0588 pd=0.7 as=0.0441 ps=0.63 w=0.42 l=0.5
X26 a_816_107# SCE a_339_655# VNB sky130_fd_pr__nfet_g5v0d10v5 ad=0.0441 pd=0.63 as=0.0588 ps=0.7 w=0.42 l=0.5
X27 a_361_107# SCD a_816_107# VNB sky130_fd_pr__nfet_g5v0d10v5 ad=0.09072 pd=0.895 as=0.0441 ps=0.63 w=0.42 l=0.5
X28 a_2014_537# a_1816_659# VGND VNB sky130_fd_pr__nfet_g5v0d10v5 ad=0.105 pd=1.03 as=0.13525 ps=1.175 w=0.75 l=0.5
X29 Q_N a_2624_107# VPWR VPB sky130_fd_pr__pfet_g5v0d10v5 ad=0.3975 pd=3.53 as=0.22185 ps=1.875 w=1.5 l=0.5
X30 a_794_655# SCD VPWR VPB sky130_fd_pr__pfet_g5v0d10v5 ad=0.0441 pd=0.63 as=0.0588 ps=0.7 w=0.42 l=0.5
X31 a_2841_81# RESET_B VPWR VPB sky130_fd_pr__pfet_g5v0d10v5 ad=0.0588 pd=0.7 as=0.0588 ps=0.7 w=0.42 l=0.5
X32 VPWR a_2624_107# a_3613_443# VPB sky130_fd_pr__pfet_g5v0d10v5 ad=0.255 pd=1.895 as=0.19875 ps=2.03 w=0.75 l=0.5
X33 a_1972_659# a_1290_126# a_1816_659# VPB sky130_fd_pr__pfet_g5v0d10v5 ad=0.0441 pd=0.63 as=0.0588 ps=0.7 w=0.42 l=0.5
X34 VPWR a_2014_537# a_1972_659# VPB sky130_fd_pr__pfet_g5v0d10v5 ad=0.0588 pd=0.7 as=0.0441 ps=0.63 w=0.42 l=0.5
X35 a_518_107# D a_361_107# VNB sky130_fd_pr__nfet_g5v0d10v5 ad=0.0441 pd=0.63 as=0.1197 ps=1.41 w=0.42 l=0.5
X36 a_339_655# a_222_131# a_518_107# VNB sky130_fd_pr__nfet_g5v0d10v5 ad=0.0588 pd=0.7 as=0.0441 ps=0.63 w=0.42 l=0.5
X37 a_1569_126# a_1290_126# VGND VNB sky130_fd_pr__nfet_g5v0d10v5 ad=0.1197 pd=1.41 as=0.1197 ps=1.41 w=0.42 l=0.5
X38 a_1999_126# a_1569_126# a_1816_659# VNB sky130_fd_pr__nfet_g5v0d10v5 ad=0.0441 pd=0.63 as=0.0588 ps=0.7 w=0.42 l=0.5
X39 a_2141_126# a_2014_537# a_1999_126# VNB sky130_fd_pr__nfet_g5v0d10v5 ad=0.0441 pd=0.63 as=0.0441 ps=0.63 w=0.42 l=0.5
X40 VGND RESET_B a_361_107# VNB sky130_fd_pr__nfet_g5v0d10v5 ad=0.0588 pd=0.7 as=0.09072 ps=0.895 w=0.42 l=0.5
X41 VGND RESET_B a_2141_126# VNB sky130_fd_pr__nfet_g5v0d10v5 ad=0.13525 pd=1.175 as=0.0441 ps=0.63 w=0.42 l=0.5
.ends
