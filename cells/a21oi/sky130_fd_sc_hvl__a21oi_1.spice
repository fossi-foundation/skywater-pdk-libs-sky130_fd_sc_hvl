* Copyright 2026 FOSSi Foundation
*
* Licensed under the Apache License, Version 2.0 (the "License");
* you may not use this file except in compliance with the License.
* You may obtain a copy of the License at
*
*	https://www.apache.org/licenses/LICENSE-2.0
*
* Unless required by applicable law or agreed to in writing, software
* distributed under the License is distributed on an "AS IS" BASIS,
* WITHOUT WARRANTIES OR CONDITIONS OF ANY KIND, either express or implied.
* See the License for the specific language governing permissions and
* limitations under the License.
*
* SPDX-License-Identifier: Apache-2.0
* NGSPICE file created from sky130_fd_sc_hvl__a21oi_1.ext - technology: sky130A

.subckt sky130_fd_sc_hvl__a21oi_1 A1 A2 B1 VGND VNB VPB VPWR Y
X0 Y A1 a_271_107# VNB sky130_fd_pr__nfet_g5v0d10v5 ad=0.1425 pd=1.13 as=0.07875 ps=0.96 w=0.75 l=0.5
X1 VGND B1 Y VNB sky130_fd_pr__nfet_g5v0d10v5 ad=0.19875 pd=2.03 as=0.1425 ps=1.13 w=0.75 l=0.5
X2 Y B1 a_56_443# VPB sky130_fd_pr__pfet_g5v0d10v5 ad=0.5475 pd=3.73 as=0.21 ps=1.78 w=1.5 l=0.5
X3 VPWR A2 a_56_443# VPB sky130_fd_pr__pfet_g5v0d10v5 ad=0.375 pd=2 as=0.4275 ps=3.57 w=1.5 l=0.5
X4 a_56_443# A1 VPWR VPB sky130_fd_pr__pfet_g5v0d10v5 ad=0.21 pd=1.78 as=0.375 ps=2 w=1.5 l=0.5
X5 a_271_107# A2 VGND VNB sky130_fd_pr__nfet_g5v0d10v5 ad=0.07875 pd=0.96 as=0.21375 ps=2.07 w=0.75 l=0.5
.ends
